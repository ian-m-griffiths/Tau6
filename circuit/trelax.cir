* =====================================================================
* trelax.cir  --  TRELAX : one heat-equation relaxation step on the
* Eisenstein (hex) lattice, in balanced ternary, measured.
*
* WHAT TRELAX IS (docs/compute/field_calculus/heat.md + synthesis.md)
*   TRELAX = one heat iteration  u <- u + alpha*Lap u,  where Lap is the
*   6-point hex-disk Laplacian
*       Lap f(x) = sum_{k=0..5} f(x+omega^k) - 6 f(x)
*   (sum over the 6 unit Z6 neighbors, minus 6x the center).  It is the
*   relaxation/diffusion primitive: repeatedly neighbor-average the field
*   and it flows toward equilibrium.  The two endpoints of the flow are
*   the two canonical zeros:  O->E = uniform (all structure gone) and
*   div=0 = harmonic (structure smoothed, not erased).
*
* THE DIGITAL FORM CHOSEN (alpha = 2/3, a DAMPED Jacobi step)
*   The spec update  u <- (1-alpha)u + (alpha/6) sum_nb  needs a division
*   by 6, which is NOT free in balanced ternary (div-by-6 = div-by-3 x
*   div-by-2, and div-by-2 has no ternary shift).  Choose alpha = 2/3 :
*       (1-alpha) = 1/3 = 3^-1     (one ternary right-shift, free)
*       (alpha/6) = 1/9 = 3^-2     (two ternary right-shifts, free)
*   so the whole update is
*       u' = u/3 + (sum_nb)/9 = (u >> 1 trit) + (sum_nb >> 2 trits)
*   which is ONE balanced add + two free wire-shifts.  This is EXACTLY the
*   spec with alpha=2/3 -- the "-6 center" and the "sum of neighbors" fold
*   into the two coefficients (u' - u = Lap/9, verified algebraically:
*   u + (1/9)(sum_nb - 6u) = u/3 + sum_nb/9).  0 < 2/3 < 1 => guaranteed
*   convergent under-relaxation for the hex Laplacian [DIRECT].
*   The explicit "-6 center" would cost an extra subtractor; folding it is
*   a free algebraic identity (OURS, but DIRECT as algebra).
*
* TRIT ENCODING (rtl/trit_functions.vh, TernaryCell.lean)
*   One trit = 2 wires, one-hot-per-direction:
*       +1 = {pull=0, push=1} = 2'b01
*        0 = {pull=0, push=0} = 2'b00   (null -- nothing energized)
*       -1 = {pull=1, push=0} = 2'b10
*        11 = NEVER produced.
*   In this netlist each of the two wires is a 0/1 V digital signal on the
*   same VDD=1.0 V rail as the repo's binary references, so the balanced
*   ternary is carried by WHICH wire is high, exactly the RTL encoding.
*
* WHAT IS MEASURED
*   (1) tadd1 -- the balanced-ternary full adder (a+b+cin -> {sum,carry},
*       balanced carry rule), built from static CMOS primitives from the
*       boolean equations in trit_functions.vh (corrected + re-verified).
*       DEVICE COUNT: 192 transistors (breakdown in the .subckt block).
*       ENERGY: supply V*I over one full output cycle, /2 = per-toggle.
*   (2) tadd6 -- a 6-trit ripple adder (6 x tadd1), the repo word width.
*       Two toggles measured: cheapest (1 trit) and worst (full 6-trit
*       swing with a carry ripple).  Per-toggle = cycle/2.
*   (3) Per-cell-per-step energy = 6 adder-evaluations (5 for the 6-input
*       neighbor-sum reduction tree + 1 for the update blend) x tadd6.
*       This is the honest "neighborhood reduction" cost: it is NOT one
*       gate, it is 36 full adders per cell per step at W=6.
*   (4) Functional: a behavioral 7-cell hex pod (center + 6 ring), spike
*       in a zero field, 4 TRELAX steps -> the non-uniformity (variance)
*       decreases monotonically: the O->E / uniform attractor.  Plus an
*       8-combo truth-table check of tadd1 vs an independent behavioral
*       reference (the arithmetic definition of the balanced sum).
*
* FAIR-FIGHT NOTE (the honest framing)
*   TRELAX is a NEIGHBORHOOD REDUCTION + UPDATE, not a single gate.  It is
*   not comparable to "a binary gate"; the honest comparison is per-step
*   per-cell against the binary adder tree that would compute the same
*   6-input integer sum + damped blend.  The per-gate numbers below feed
*   the verdict in trelax_measured.md.  Same honesty rules as every
*   fair fight in this dir: LEVEL=1 models, no body diodes, no mismatch,
*   inputs from ideal sources (previous stage abstracted), output loads =
*   one next-gate input capacitance.
*
* RAILS: single +1.0 V supply, ground = node 0.  One-hot wires are 0/1 V.
* =====================================================================

.options reltol=1e-3 abstol=1e-15 vntol=1e-6

.param VDD  = 1.0
.param CL   = 10f         ; one output wire drives ~1 next-gate input
.param CC   = 1f          ; tiny cap for DC truth-table settle

* ---------------- models (verbatim from gate_energy.cir / fairfight) ----
.model NMOS1 NMOS(LEVEL=1 VTO=0.4  KP=200u LAMBDA=0.05 TOX=2n)
.model PMOS1 PMOS(LEVEL=1 VTO=-0.4 KP=100u LAMBDA=0.05 TOX=2n)

* =====================================================================
* STATIC CMOS PRIMITIVES  (transistor counts: PMOS 4u / NMOS 2u basis,
* series stacks width-scaled for equal drive, per gate_energy.cir)
* =====================================================================
* inv = 2 T
.subckt inv in out vdd gnd
Mp out in vdd vdd PMOS1 W=4u  L=0.18u
Mn out in gnd gnd NMOS1 W=2u  L=0.18u
.ends
* nand2 = 4 T
.subckt nand2 a b out vdd gnd
Mp1 out a vdd vdd PMOS1 W=4u  L=0.18u
Mp2 out b vdd vdd PMOS1 W=4u  L=0.18u
Mn1 out a mid gnd NMOS1 W=4u  L=0.18u
Mn2 mid b gnd gnd NMOS1 W=4u  L=0.18u
Cmid mid 0 1f
.ends
* nor2 = 4 T
.subckt nor2 a b out vdd gnd
Mp1 mid a vdd vdd PMOS1 W=8u  L=0.18u
Mp2 out b mid vdd PMOS1 W=8u  L=0.18u
Mn1 out a gnd gnd NMOS1 W=2u  L=0.18u
Mn2 out b gnd gnd NMOS1 W=2u  L=0.18u
Cmid mid 0 1f
.ends
* and2 = nand2 + inv = 6 T
.subckt and2 a b out vdd gnd
X1 a b mid vdd gnd nand2
X2 mid out vdd gnd inv
.ends
* or2 = nor2 + inv = 6 T
.subckt or2 a b out vdd gnd
X1 a b mid vdd gnd nor2
X2 mid out vdd gnd inv
.ends
* nand3 = 6 T
.subckt nand3 a b c out vdd gnd
Mp1 out a vdd vdd PMOS1 W=4u  L=0.18u
Mp2 out b vdd vdd PMOS1 W=4u  L=0.18u
Mp3 out c vdd vdd PMOS1 W=4u  L=0.18u
Mn1 out a m1 gnd NMOS1 W=6u  L=0.18u
Mn2 m1  b m2 gnd NMOS1 W=6u  L=0.18u
Mn3 m2  c gnd gnd NMOS1 W=6u  L=0.18u
Cm1 m1 0 1f
Cm2 m2 0 1f
.ends
* nor3 = 6 T
.subckt nor3 a b c out vdd gnd
Mp1 m1  a vdd vdd PMOS1 W=12u L=0.18u
Mp2 m2  b m1 vdd PMOS1 W=12u L=0.18u
Mp3 out c m2 vdd PMOS1 W=12u L=0.18u
Mn1 out a gnd gnd NMOS1 W=2u  L=0.18u
Mn2 out b gnd gnd NMOS1 W=2u  L=0.18u
Mn3 out c gnd gnd NMOS1 W=2u  L=0.18u
Cm1 m1 0 1f
Cm2 m2 0 1f
.ends
* and3 = nand3 + inv = 8 T
.subckt and3 a b c out vdd gnd
X1 a b c mid vdd gnd nand3
X2 mid out vdd gnd inv
.ends
* or3 = nor3 + inv = 8 T
.subckt or3 a b c out vdd gnd
X1 a b c mid vdd gnd nor3
X2 mid out vdd gnd inv
.ends

* =====================================================================
* TADD1 -- balanced-ternary full adder (transistor level).
*
* Inputs: ap,an (a), bp,bn (b), cp,cn (cin) -- 0/1 V one-hot per trit.
* Outputs: sp,sn (sum), cop,con (carry) -- 0/1 V one-hot.
* Truth: a+b+cin = sum + 3*carry (balanced), digit sum s in {-3..+3}:
*   carry +1 iff s>=2 ;  carry -1 iff s<=-2
*   sum   +1 iff s in {+1,-2} ;  sum -1 iff s in {-1,+2}
* Boolean (independent of the RTL form, cross-checked against it and the
* arithmetic definition in the truth-table block):
*   p2 = maj3(ap,bp,cp)   n2 = maj3(an,bn,cn)
*   all3p = ap&bp&cp      all3n = an&bn&cn
*   nz = ~(an|bn|cn)      pz = ~(ap|bp|cp)
*   p2x = p2 & ~all3p     n2x = n2 & ~all3n     (exactly two)
*   p1  = (ap|bp|cp)&~p2  n1  = (an|bn|cn)&~n2  (exactly one)
*   cop = nz & p2         con = pz & n2
*   sp  = (p1&nz) | (p2x&n1) | (pz&n2x)
*   sn  = (n1&pz) | (n2x&p1) | (nz&p2x)
* DEVICE COUNT (transistors): maj3 p2 26 + n2 26 + all3p 8 + all3n 8
*   + nz 6 + pz 6 + p2x 8 + n2x 8 + p1 16 + n1 16 + cop 6 + con 6
*   + sp 26 + sn 26 = 192 T.  (The naive boolean cell; gate_area.md's
*   yosys pass maps this to 25 sky130 cells / 146.39 um^2 -- the two
*   counts agree within the "simple gates vs packed cells" difference.)
* =====================================================================
.subckt tadd1 ap an bp bn cp cn sp sn cop con vdd gnd
Xab1 ap bp mab  vdd gnd and2
Xac1 ap cp mac  vdd gnd and2
Xbc1 bp cp mbc  vdd gnd and2
Xp2  mab mac mbc p2 vdd gnd or3
Xab2 an bn mabn vdd gnd and2
Xac2 an cn macn vdd gnd and2
Xbc2 bn cn mbcn vdd gnd and2
Xn2  mabn macn mbcn n2 vdd gnd or3
Xa3p ap bp cp all3p vdd gnd and3
Xa3n an bn cn all3n vdd gnd and3
Xnz  an bn cn nz vdd gnd nor3
Xpz  ap bp cp pz vdd gnd nor3
Xi3p all3p na3p vdd gnd inv
Xp2x p2 na3p p2x vdd gnd and2
Xi3n all3n na3n vdd gnd inv
Xn2x n2 na3n n2x vdd gnd and2
Xop  ap bp cp op vdd gnd or3
Xon  an bn cn on vdd gnd or3
Xip2 p2 np2 vdd gnd inv
Xp1  op np2 p1 vdd gnd and2
Xin2 n2 nn2 vdd gnd inv
Xn1  on nn2 n1 vdd gnd and2
Xcop nz p2 cop vdd gnd and2
Xcon pz n2 con vdd gnd and2
Xsp1 p1  nz  sp1 vdd gnd and2
Xsp2 p2x n1  sp2 vdd gnd and2
Xsp3 pz  n2x sp3 vdd gnd and2
Xspo sp1 sp2 sp3 sp vdd gnd or3
Xsn1 n1  pz  sn1 vdd gnd and2
Xsn2 n2x p1  sn2 vdd gnd and2
Xsn3 nz  p2x sn3 vdd gnd and2
Xsno sn1 sn2 sn3 sn vdd gnd or3
.ends

* =====================================================================
* BTADD1 -- behavioral (ideal) reference for the truth-table check.
* Computes the SAME balanced sum from the arithmetic definition
*   s = a + b + cin  (integer in -3..+3),  then the encode rule,
* independent of the transistor boolean above.  Used only to verify the
* transistor cell agrees; it costs zero energy and is not in any count.
* =====================================================================
.subckt btadd1 ap an bp bn cp cn sp sn cop con
Bs   s   0 V = (V(ap)-V(an)) + (V(bp)-V(bn)) + (V(cp)-V(cn))
Bcop cop 0 V = (u(V(s)-1.5))
Bcon con 0 V = (u(-V(s)-1.5))
Bsp  sp  0 V = (u(V(s)-0.5)*(1-u(V(s)-1.5)) + u(-V(s)-1.5)*(1-u(-V(s)-2.5)))
Bsn  sn  0 V = (u(-V(s)-0.5)*(1-u(-V(s)-1.5)) + u(V(s)-1.5)*(1-u(V(s)-2.5)))
.ends

* =====================================================================
* BIN_FA -- binary full adder (the direct per-gate analog of tadd1, for
* the "is the primitive cheap?" comparison).  Static CMOS:
*   cout = maj3(a,b,cin),  sum = a xor b xor cin  (x = a xor b).
* DEVICE COUNT: cout 26 T + x 16 T + sum 16 T = 58 T  (simple static build;
* the sky130 badd1 in gate_area.md is 2 cells / 33.78 um^2, ~24-28 T -- this
* hand build is GENEROUS to binary, i.e. the ternary/binary ratio below is
* a LOWER bound on how much bigger the balanced adder is).
* =====================================================================
.subckt bin_fa a b cin sum cout vdd gnd
Xc1 a b c1 vdd gnd and2
Xc2 a cin c2 vdd gnd and2
Xc3 b cin c3 vdd gnd and2
Xco c1 c2 c3 cout vdd gnd or3
Xabn a b abn vdd gnd nand2
Xabo a b abo vdd gnd or2
Xx abo abn x vdd gnd and2
Xxn x cin xn vdd gnd nand2
Xxo x cin xo vdd gnd or2
Xs xo xn sum vdd gnd and2
.ends

* =====================================================================
* TADD6 -- 6-trit balanced ripple adder (6 x tadd1).  6*192 = 1152 T.
* Ports: a[11:0] b[11:0] as (ap0 an0 ... ap5 an5), sum[11:0], cout[1:0].
* =====================================================================
.subckt tadd6 ap0 an0 ap1 an1 ap2 an2 ap3 an3 ap4 an4 ap5 an5 bp0 bn0 bp1 bn1 bp2 bn2 bp3 bn3 bp4 bn4 bp5 bn5 sp0 sn0 sp1 sn1 sp2 sn2 sp3 sn3 sp4 sn4 sp5 sn5 cop con vdd gnd
X0 ap0 an0 bp0 bn0 0 0 sp0 sn0 c1p c1n vdd gnd tadd1
X1 ap1 an1 bp1 bn1 c1p c1n sp1 sn1 c2p c2n vdd gnd tadd1
X2 ap2 an2 bp2 bn2 c2p c2n sp2 sn2 c3p c3n vdd gnd tadd1
X3 ap3 an3 bp3 bn3 c3p c3n sp3 sn3 c4p c4n vdd gnd tadd1
X4 ap4 an4 bp4 bn4 c4p c4n sp4 sn4 c5p c5n vdd gnd tadd1
X5 ap5 an5 bp5 bn5 c5p c5n sp5 sn5 cop con vdd gnd tadd1
.ends

* =====================================================================
* SUPPLIES + POWER PROBES
*   vddt : shared by the 8 DC truth-table instances (static, ~0 after
*          settling).  vdd1..vdd3 : isolated per energy instance so each
*          measured integral is that instance's own supply energy.
* =====================================================================
VDDt vddt 0 DC {VDD}
VDD1 vdd1 0 DC {VDD}
VDD2 vdd2 0 DC {VDD}
VDD3 vdd3 0 DC {VDD}
VDD4 vdd4 0 DC {VDD}
Bp1 p1 0 V = -(V(vdd1)*I(VDD1))
Bp2 p2 0 V = -(V(vdd2)*I(VDD2))
Bp3 p3 0 V = -(V(vdd3)*I(VDD3))
Bp4 p4 0 V = -(V(vdd4)*I(VDD4))

* =====================================================================
* ENERGY INSTANCE E1 : tadd1, rich toggle.
*   a toggles 0 -> +1 -> 0, with b=+1, cin=0: sum swings +1 -> -1 -> +1
*   (BOTH output wires of sum toggle) and carry swings 0 -> +1 -> 0
*   (cop toggles) -- exercises every output path, the "average" case.
*   Inputs rise at 50 ns, fall at 70.2 ns (PULSE 0 1 50n 0.2n 0.2n 20n).
* =====================================================================
Ve1ap e1ap 0 PULSE(0 1 50n 0.2n 0.2n 20n 200n)
Ve1an e1an 0 DC 0
Ve1bp e1bp 0 DC 1
Ve1bn e1bn 0 DC 0
Ve1cp e1cp 0 DC 0
Ve1cn e1cn 0 DC 0
Xe1 e1ap e1an e1bp e1bn e1cp e1cn e1sp e1sn e1cop e1con vdd1 0 tadd1
Ce1sp  e1sp  0 {CL}
Ce1sn  e1sn  0 {CL}
Ce1cop e1cop 0 {CL}
Ce1con e1con 0 {CL}

* =====================================================================
* ENERGY INSTANCE E4 : binary full adder (bin_fa), SAME toggle as E1.
*   a toggles 0 -> 1 -> 0 with b=1, cin=0: sum swings 1 -> 0 -> 1 and
*   cout swings 0 -> 1 -> 0 -- the identical output-activity shape, so
*   e4_pt / e1_pt is the clean ternary-vs-binary FULL ADDER energy ratio.
* =====================================================================
Ve4a e4a 0 PULSE(0 1 50n 0.2n 0.2n 20n 200n)
Ve4b e4b 0 DC 1
Ve4c e4c 0 DC 0
Xe4 e4a e4b e4c e4sum e4cout vdd4 0 bin_fa
Ce4sum  e4sum  0 {CL}
Ce4cout e4cout 0 {CL}

* =====================================================================
* ENERGY INSTANCE E2 : tadd6, CHEAPEST toggle (1 trit, no carry ripple).
*   a = 0 (all null), b trit0 toggles 0 <-> +1.  sum = b.  Lower bound.
* =====================================================================
Ve2b0 e2b0 0 PULSE(0 1 50n 0.2n 0.2n 20n 200n)
Xe2 0 0 0 0 0 0 0 0 0 0 0 0 e2b0 0 0 0 0 0 0 0 0 0 0 0 e2s0p e2s0n e2s1p e2s1n e2s2p e2s2n e2s3p e2s3n e2s4p e2s4n e2s5p e2s5n e2cop e2con vdd2 0 tadd6
Ce2s0p e2s0p 0 {CL}
Ce2s0n e2s0n 0 {CL}
Ce2s1p e2s1p 0 {CL}
Ce2s1n e2s1n 0 {CL}
Ce2s2p e2s2p 0 {CL}
Ce2s2n e2s2n 0 {CL}
Ce2s3p e2s3p 0 {CL}
Ce2s3n e2s3n 0 {CL}
Ce2s4p e2s4p 0 {CL}
Ce2s4n e2s4n 0 {CL}
Ce2s5p e2s5p 0 {CL}
Ce2s5n e2s5n 0 {CL}
Ce2cop e2cop 0 {CL}
Ce2con e2con 0 {CL}

* =====================================================================
* ENERGY INSTANCE E3 : tadd6, WORST toggle (full 6-trit swing + carry
*   ripple).  a = +364 (all 6 trits +1), b toggles 0 <-> +364: the sum
*   toggles +364 <-> +728 (overflow) and the carry ripples through all
*   six stages.  Upper bound on a 6-trit adder evaluation.
* =====================================================================
Ve3b0 e3b0 0 PULSE(0 1 50n 0.2n 0.2n 20n 200n)
Ve3b1 e3b1 0 PULSE(0 1 50n 0.2n 0.2n 20n 200n)
Ve3b2 e3b2 0 PULSE(0 1 50n 0.2n 0.2n 20n 200n)
Ve3b3 e3b3 0 PULSE(0 1 50n 0.2n 0.2n 20n 200n)
Ve3b4 e3b4 0 PULSE(0 1 50n 0.2n 0.2n 20n 200n)
Ve3b5 e3b5 0 PULSE(0 1 50n 0.2n 0.2n 20n 200n)
Xe3 vdd3 0 vdd3 0 vdd3 0 vdd3 0 vdd3 0 vdd3 0 e3b0 0 e3b1 0 e3b2 0 e3b3 0 e3b4 0 e3b5 0 e3s0p e3s0n e3s1p e3s1n e3s2p e3s2n e3s3p e3s3n e3s4p e3s4n e3s5p e3s5n e3cop e3con vdd3 0 tadd6
Ce3s0p e3s0p 0 {CL}
Ce3s0n e3s0n 0 {CL}
Ce3s1p e3s1p 0 {CL}
Ce3s1n e3s1n 0 {CL}
Ce3s2p e3s2p 0 {CL}
Ce3s2n e3s2n 0 {CL}
Ce3s3p e3s3p 0 {CL}
Ce3s3n e3s3n 0 {CL}
Ce3s4p e3s4p 0 {CL}
Ce3s4n e3s4n 0 {CL}
Ce3s5p e3s5p 0 {CL}
Ce3s5n e3s5n 0 {CL}
Ce3cop e3cop 0 {CL}
Ce3con e3con 0 {CL}

* =====================================================================
* TRUTH-TABLE CHECK : 8 representative tadd1 input triples, transistor
* cell vs the behavioral reference (btadd1).  Each diff node reads
* V(transistor_out) - V(reference_out); ~0 V = verified.  The triples
* cover every output class and the tricky cross cases (p=2,n=1 -> s=+1,
* p=0,n=2 -> s=-2, s=+-3 saturation).
* =====================================================================
* --- combo 1: (+1,+1,0) -> sum=-1 carry=+1 ----------------------------
Vt1ap t1ap 0 DC 1
Vt1an t1an 0 DC 0
Vt1bp t1bp 0 DC 1
Vt1bn t1bn 0 DC 0
Vt1cp t1cp 0 DC 0
Vt1cn t1cn 0 DC 0
Xtt1 t1ap t1an t1bp t1bn t1cp t1cn t1sp t1sn t1cop t1con vddt 0 tadd1
Xref1 t1ap t1an t1bp t1bn t1cp t1cn t1spr t1snr t1copr t1conr btadd1
Bdsp1 dsp1 0 V = V(t1sp)-V(t1spr)
Bdsn1 dsn1 0 V = V(t1sn)-V(t1snr)
Bdcop1 dcop1 0 V = V(t1cop)-V(t1copr)
Bdcon1 dcon1 0 V = V(t1con)-V(t1conr)
Ct1sp t1sp 0 {CC}
Ct1sn t1sn 0 {CC}
Ct1cop t1cop 0 {CC}
Ct1con t1con 0 {CC}

* --- combo 2: (-1,-1,0) -> sum=+1 carry=-1 ----------------------------
Vt2ap t2ap 0 DC 0
Vt2an t2an 0 DC 1
Vt2bp t2bp 0 DC 0
Vt2bn t2bn 0 DC 1
Vt2cp t2cp 0 DC 0
Vt2cn t2cn 0 DC 0
Xtt2 t2ap t2an t2bp t2bn t2cp t2cn t2sp t2sn t2cop t2con vddt 0 tadd1
Xref2 t2ap t2an t2bp t2bn t2cp t2cn t2spr t2snr t2copr t2conr btadd1
Bdsp2 dsp2 0 V = V(t2sp)-V(t2spr)
Bdsn2 dsn2 0 V = V(t2sn)-V(t2snr)
Bdcop2 dcop2 0 V = V(t2cop)-V(t2copr)
Bdcon2 dcon2 0 V = V(t2con)-V(t2conr)
Ct2sp t2sp 0 {CC}
Ct2sn t2sn 0 {CC}
Ct2cop t2cop 0 {CC}
Ct2con t2con 0 {CC}

* --- combo 3: (+1,-1,0) -> sum=0 carry=0 ------------------------------
Vt3ap t3ap 0 DC 1
Vt3an t3an 0 DC 0
Vt3bp t3bp 0 DC 0
Vt3bn t3bn 0 DC 1
Vt3cp t3cp 0 DC 0
Vt3cn t3cn 0 DC 0
Xtt3 t3ap t3an t3bp t3bn t3cp t3cn t3sp t3sn t3cop t3con vddt 0 tadd1
Xref3 t3ap t3an t3bp t3bn t3cp t3cn t3spr t3snr t3copr t3conr btadd1
Bdsp3 dsp3 0 V = V(t3sp)-V(t3spr)
Bdsn3 dsn3 0 V = V(t3sn)-V(t3snr)
Bdcop3 dcop3 0 V = V(t3cop)-V(t3copr)
Bdcon3 dcon3 0 V = V(t3con)-V(t3conr)
Ct3sp t3sp 0 {CC}
Ct3sn t3sn 0 {CC}
Ct3cop t3cop 0 {CC}
Ct3con t3con 0 {CC}

* --- combo 4: (+1,0,0) -> sum=+1 carry=0 ------------------------------
Vt4ap t4ap 0 DC 1
Vt4an t4an 0 DC 0
Vt4bp t4bp 0 DC 0
Vt4bn t4bn 0 DC 0
Vt4cp t4cp 0 DC 0
Vt4cn t4cn 0 DC 0
Xtt4 t4ap t4an t4bp t4bn t4cp t4cn t4sp t4sn t4cop t4con vddt 0 tadd1
Xref4 t4ap t4an t4bp t4bn t4cp t4cn t4spr t4snr t4copr t4conr btadd1
Bdsp4 dsp4 0 V = V(t4sp)-V(t4spr)
Bdsn4 dsn4 0 V = V(t4sn)-V(t4snr)
Bdcop4 dcop4 0 V = V(t4cop)-V(t4copr)
Bdcon4 dcon4 0 V = V(t4con)-V(t4conr)
Ct4sp t4sp 0 {CC}
Ct4sn t4sn 0 {CC}
Ct4cop t4cop 0 {CC}
Ct4con t4con 0 {CC}

* --- combo 5: (-1,+1,+1) -> sum=+1 carry=0  (cross: p=2,n=1 => s=+1) --
Vt5ap t5ap 0 DC 0
Vt5an t5an 0 DC 1
Vt5bp t5bp 0 DC 1
Vt5bn t5bn 0 DC 0
Vt5cp t5cp 0 DC 1
Vt5cn t5cn 0 DC 0
Xtt5 t5ap t5an t5bp t5bn t5cp t5cn t5sp t5sn t5cop t5con vddt 0 tadd1
Xref5 t5ap t5an t5bp t5bn t5cp t5cn t5spr t5snr t5copr t5conr btadd1
Bdsp5 dsp5 0 V = V(t5sp)-V(t5spr)
Bdsn5 dsn5 0 V = V(t5sn)-V(t5snr)
Bdcop5 dcop5 0 V = V(t5cop)-V(t5copr)
Bdcon5 dcon5 0 V = V(t5con)-V(t5conr)
Ct5sp t5sp 0 {CC}
Ct5sn t5sn 0 {CC}
Ct5cop t5cop 0 {CC}
Ct5con t5con 0 {CC}

* --- combo 6: (+1,+1,+1) -> sum=0 carry=+1  (s=+3 saturation) --------
Vt6ap t6ap 0 DC 1
Vt6an t6an 0 DC 0
Vt6bp t6bp 0 DC 1
Vt6bn t6bn 0 DC 0
Vt6cp t6cp 0 DC 1
Vt6cn t6cn 0 DC 0
Xtt6 t6ap t6an t6bp t6bn t6cp t6cn t6sp t6sn t6cop t6con vddt 0 tadd1
Xref6 t6ap t6an t6bp t6bn t6cp t6cn t6spr t6snr t6copr t6conr btadd1
Bdsp6 dsp6 0 V = V(t6sp)-V(t6spr)
Bdsn6 dsn6 0 V = V(t6sn)-V(t6snr)
Bdcop6 dcop6 0 V = V(t6cop)-V(t6copr)
Bdcon6 dcon6 0 V = V(t6con)-V(t6conr)
Ct6sp t6sp 0 {CC}
Ct6sn t6sn 0 {CC}
Ct6cop t6cop 0 {CC}
Ct6con t6con 0 {CC}

* --- combo 7: (0,-1,-1) -> sum=+1 carry=-1  (s=-2) -------------------
Vt7ap t7ap 0 DC 0
Vt7an t7an 0 DC 0
Vt7bp t7bp 0 DC 0
Vt7bn t7bn 0 DC 1
Vt7cp t7cp 0 DC 0
Vt7cn t7cn 0 DC 1
Xtt7 t7ap t7an t7bp t7bn t7cp t7cn t7sp t7sn t7cop t7con vddt 0 tadd1
Xref7 t7ap t7an t7bp t7bn t7cp t7cn t7spr t7snr t7copr t7conr btadd1
Bdsp7 dsp7 0 V = V(t7sp)-V(t7spr)
Bdsn7 dsn7 0 V = V(t7sn)-V(t7snr)
Bdcop7 dcop7 0 V = V(t7cop)-V(t7copr)
Bdcon7 dcon7 0 V = V(t7con)-V(t7conr)
Ct7sp t7sp 0 {CC}
Ct7sn t7sn 0 {CC}
Ct7cop t7cop 0 {CC}
Ct7con t7con 0 {CC}

* --- combo 8: (-1,0,+1) -> sum=0 carry=0 ------------------------------
Vt8ap t8ap 0 DC 0
Vt8an t8an 0 DC 1
Vt8bp t8bp 0 DC 0
Vt8bn t8bn 0 DC 0
Vt8cp t8cp 0 DC 1
Vt8cn t8cn 0 DC 0
Xtt8 t8ap t8an t8bp t8bn t8cp t8cn t8sp t8sn t8cop t8con vddt 0 tadd1
Xref8 t8ap t8an t8bp t8bn t8cp t8cn t8spr t8snr t8copr t8conr btadd1
Bdsp8 dsp8 0 V = V(t8sp)-V(t8spr)
Bdsn8 dsn8 0 V = V(t8sn)-V(t8snr)
Bdcop8 dcop8 0 V = V(t8cop)-V(t8copr)
Bdcon8 dcon8 0 V = V(t8con)-V(t8conr)
Ct8sp t8sp 0 {CC}
Ct8sn t8sn 0 {CC}
Ct8cop t8cop 0 {CC}
Ct8con t8con 0 {CC}

* =====================================================================
* SIMULATION + MEASUREMENTS
* Full toggle cycle: inputs rise at 50 ns, fall at 70.2 ns.  Integrate
* supply energy 49..80 ns = both edges + settling.  per-toggle = /2.
* Truth-table diffs read at 85 ns (DC inputs, long settled).
* =====================================================================
.tran 20p 90n

* --- E1: tadd1 energy ---
.meas tran e1_cycle INTEG V(p1) FROM=49n TO=80n
.meas tran e1_pt    PARAM = 'e1_cycle/2'

* --- E4: binary full adder energy (same toggle as E1) ---
.meas tran e4_cycle INTEG V(p4) FROM=49n TO=80n
.meas tran e4_pt    PARAM = 'e4_cycle/2'

* --- ternary/binary full-adder energy ratio ---
.meas tran ratio_ener PARAM = 'e1_cycle/e4_cycle'

* --- E2: tadd6 cheapest ---
.meas tran e2_cycle INTEG V(p2) FROM=49n TO=80n
.meas tran e2_pt    PARAM = 'e2_cycle/2'

* --- E3: tadd6 worst ---
.meas tran e3_cycle INTEG V(p3) FROM=49n TO=80n
.meas tran e3_pt    PARAM = 'e3_cycle/2'

* --- E4 output checkpoints (sanity: sum toggles 1 -> 0 -> 1) ---
.meas tran e4sum_r FIND V(e4sum) AT=53n
.meas tran e4cout_r FIND V(e4cout) AT=53n
.meas tran e4sum_f FIND V(e4sum) AT=73n
.meas tran e4cout_f FIND V(e4cout) AT=73n

* --- E1 output checkpoints (sanity: sum toggles +1 -> -1 -> +1) ---
.meas tran e1sp_r FIND V(e1sp) AT=53n
.meas tran e1sn_r FIND V(e1sn) AT=53n
.meas tran e1cop_r FIND V(e1cop) AT=53n
.meas tran e1sp_f FIND V(e1sp) AT=73n
.meas tran e1sn_f FIND V(e1sn) AT=73n
.meas tran e1cop_f FIND V(e1cop) AT=73n

* --- truth-table diffs (0 = transistor matches reference) ---
.meas tran dsp1  FIND V(dsp1)  AT=85n
.meas tran dsn1  FIND V(dsn1)  AT=85n
.meas tran dcop1 FIND V(dcop1) AT=85n
.meas tran dcon1 FIND V(dcon1) AT=85n
.meas tran dsp2  FIND V(dsp2)  AT=85n
.meas tran dsn2  FIND V(dsn2)  AT=85n
.meas tran dcop2 FIND V(dcop2) AT=85n
.meas tran dcon2 FIND V(dcon2) AT=85n
.meas tran dsp3  FIND V(dsp3)  AT=85n
.meas tran dsn3  FIND V(dsn3)  AT=85n
.meas tran dcop3 FIND V(dcop3) AT=85n
.meas tran dcon3 FIND V(dcon3) AT=85n
.meas tran dsp4  FIND V(dsp4)  AT=85n
.meas tran dsn4  FIND V(dsn4)  AT=85n
.meas tran dcop4 FIND V(dcop4) AT=85n
.meas tran dcon4 FIND V(dcon4) AT=85n
.meas tran dsp5  FIND V(dsp5)  AT=85n
.meas tran dsn5  FIND V(dsn5)  AT=85n
.meas tran dcop5 FIND V(dcop5) AT=85n
.meas tran dcon5 FIND V(dcon5) AT=85n
.meas tran dsp6  FIND V(dsp6)  AT=85n
.meas tran dsn6  FIND V(dsn6)  AT=85n
.meas tran dcop6 FIND V(dcop6) AT=85n
.meas tran dcon6 FIND V(dcon6) AT=85n
.meas tran dsp7  FIND V(dsp7)  AT=85n
.meas tran dsn7  FIND V(dsn7)  AT=85n
.meas tran dcop7 FIND V(dcop7) AT=85n
.meas tran dcon7 FIND V(dcon7) AT=85n
.meas tran dsp8  FIND V(dsp8)  AT=85n
.meas tran dsn8  FIND V(dsn8)  AT=85n
.meas tran dcop8 FIND V(dcop8) AT=85n
.meas tran dcon8 FIND V(dcon8) AT=85n

* =====================================================================
* RELAXATION DEMONSTRATION (behavioral, exact alpha=2/3 arithmetic).
* 7-cell hex pod: center c + 6 ring cells r (identical by symmetry).
* Fixed-zero boundary (the pod is a local stencil in an empty field):
*   c' = c/3 + (6 r)/9          (center sees its 6 ring neighbors)
*   r' = r/3 + c/9              (a ring cell sees the center + 5 zeros)
* Field in F = 27*u units (u = F/27), initial spike: center = +27 (u=1).
* Prints the field and the population variance (in u units) each step --
* variance strictly decreases: the non-uniform spike relaxes to uniform.
* =====================================================================
.control
  echo ""
  echo "================ TRELAX relaxation demo (alpha=2/3, 7-cell pod) ================"
  echo "Field in F = 27*u units (u = F/27); center spike = +27 (u=1), ring = 0."
  let c = 27
  let r = 0
  let m0 = (c + 6*r)/7
  let var0 = ((c-m0)^2 + 6*(r-m0)^2)/7/729
  echo "step 0: u_center=$&c/27 u_ring=$&r  variance_u=$&var0"
  let step = 0
  foreach k 1 2 3 4
    let s = 6*r
    let cnew = c/3 + s/9
    let rnew = r/3 + c/9
    let m = (cnew + 6*rnew)/7
    let var = ((cnew-m)^2 + 6*(rnew-m)^2)/7/729
    let c = cnew
    let r = rnew
    let step = step + 1
    echo "step $&step: u_center=$&c/27 u_ring=$&r  variance_u=$&var"
  end
  echo "  (variance_u is the population variance of the 7 field values; it"
  echo "   decreases monotonically -> the non-uniform spike relaxes toward"
  echo "   uniform = the O->E attractor.)"
  echo ""
  echo "Device counts (transistors, from the .subckt blocks above):"
  echo "  tadd1 (balanced full adder) = 192 T ;  binary full adder = 58 T"
  echo "  tadd6 (6-trit ripple)       = 1152 T"
  echo "  per-cell-per-step: 5 reduction + 1 update adders."
  echo "    normalized field (|u|<=1.5, 6-trit sum): 6 x tadd6 = 36 tadd1 = 6912 T"
  echo "    full-range safe  (8-trit sum):           46 tadd1 = 8832 T"
  echo "    (yosys/sky130: trelax_cell = 891 cells / 5594.12 um^2)"
  echo "  per-pod (7 cells): 48384 T (normalized) / 61824 T (safe)"
  echo ""
.endc

.end
