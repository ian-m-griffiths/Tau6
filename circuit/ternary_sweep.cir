* =====================================================================
* ternary_sweep.cir  --  lever sweep of the AC-polarity ternary cell
* Generated by make_ternary_sweep.py (do not edit by hand).
*
* Levers swept (full grid, 96 instances):
*   diode : DIDEAL (IS=1e-14) / DSCHOTTKY (IS=1e-9, Vf~0.35V)
*   IP    : 0.2m, 0.5m, 1m        pulse amplitude
*   PW    : 0.5n, 1n, 3n, 10n     pulse width (rise=fall=PW/5)
*   RW    : 100, 500              wire resistance
*   CLINE : 0.5p, 1p              wire capacitance
*
* Each instance is a full 4-case cell (push / pull / push->pull cycle);
* energy = INTEG V(drv)*I(Vs) over the transfer window at the driver.
* Measure windows are fixed literals: any window tail after the pulse
* sees zero driver current, so it adds nothing to the integral.
* =====================================================================

.options reltol=1e-3 abstol=1e-15 vntol=1e-6

* ---------- diode models ----------
.model DIDEAL D (IS=1e-14 RS=50 CJO=0.2p TT=2n N=1.0)
.model DSCHOTTKY D (IS=1e-9 RS=50 CJO=0.2p TT=1n N=1.05)

* ---------- parametrized cells (one per diode model) ----------
.subckt ternary_case vss ip=1m pw=3n rw=500 cl=1p
* ---- push (+1): 1mA pulse into the wire at 10..~14n ----
IpA 0 dA PULSE(0 {ip} 10n {pw/5} {pw/5} {pw} 200n)
VsA dA drvA DC 0
RwA drvA xA {rw}
CxA xA 0 {cl}
RtermA xA 0 1meg
D1A xA rAp DIDEAL
D2A rBp xA DIDEAL
RLAA rAp 0 500
CLAA rAp 0 0.2p
RLAB rBp 0 500
CLAB rBp 0 0.2p
BpA pwpA 0 V = V(drvA)*I(VsA)
* ---- pull (-1): -1mA at 40..~44n ----
IpB 0 dB PULSE(0 {-ip} 40n {pw/5} {pw/5} {pw} 200n)
VsB dB drvB DC 0
RwB drvB xB {rw}
CxB xB 0 {cl}
RtermB xB 0 1meg
D1B xB rAq DIDEAL
D2B rBq xB DIDEAL
RLBA rAq 0 500
CLBA rAq 0 0.2p
RLBB rBq 0 500
CLBB rBq 0 0.2p
BpB pwpB 0 V = V(drvB)*I(VsB)
* ---- push then pull back-to-back (charge recycling), 100n / 124n ----
Icy1 0 dC PULSE(0 {ip} 100n {pw/5} {pw/5} {pw} 200n)
Icy2 0 dC PULSE(0 {-ip} 124n {pw/5} {pw/5} {pw} 200n)
VsC dC drvC DC 0
RwC drvC xC {rw}
CxC xC 0 {cl}
RtermC xC 0 1meg
D1C xC rAc DIDEAL
D2C rBc xC DIDEAL
RLCA rAc 0 500
CLCA rAc 0 0.2p
RLCB rBc 0 500
CLCB rBc 0 0.2p
BpC pwpC 0 V = V(drvC)*I(VsC)
.ends

.subckt ternary_case_s vss ip=1m pw=3n rw=500 cl=1p
* ---- push (+1): 1mA pulse into the wire at 10..~14n ----
IpA 0 dA PULSE(0 {ip} 10n {pw/5} {pw/5} {pw} 200n)
VsA dA drvA DC 0
RwA drvA xA {rw}
CxA xA 0 {cl}
RtermA xA 0 1meg
D1A xA rAp DSCHOTTKY
D2A rBp xA DSCHOTTKY
RLAA rAp 0 500
CLAA rAp 0 0.2p
RLAB rBp 0 500
CLAB rBp 0 0.2p
BpA pwpA 0 V = V(drvA)*I(VsA)
* ---- pull (-1): -1mA at 40..~44n ----
IpB 0 dB PULSE(0 {-ip} 40n {pw/5} {pw/5} {pw} 200n)
VsB dB drvB DC 0
RwB drvB xB {rw}
CxB xB 0 {cl}
RtermB xB 0 1meg
D1B xB rAq DSCHOTTKY
D2B rBq xB DSCHOTTKY
RLBA rAq 0 500
CLBA rAq 0 0.2p
RLBB rBq 0 500
CLBB rBq 0 0.2p
BpB pwpB 0 V = V(drvB)*I(VsB)
* ---- push then pull back-to-back (charge recycling), 100n / 124n ----
Icy1 0 dC PULSE(0 {ip} 100n {pw/5} {pw/5} {pw} 200n)
Icy2 0 dC PULSE(0 {-ip} 124n {pw/5} {pw/5} {pw} 200n)
VsC dC drvC DC 0
RwC drvC xC {rw}
CxC xC 0 {cl}
RtermC xC 0 1meg
D1C xC rAc DSCHOTTKY
D2C rBc xC DSCHOTTKY
RLCA rAc 0 500
CLCA rAc 0 0.2p
RLCB rBc 0 500
CLCB rBc 0 0.2p
BpC pwpC 0 V = V(drvC)*I(VsC)
.ends

* ---------- 96 sweep instances (model x IP x PW x RW x CLINE) ----------
X_ID_02_05_100_05 vss ternary_case ip=0.2m pw=0.5n rw=100 cl=0.5p
X_ID_02_05_100_10 vss ternary_case ip=0.2m pw=0.5n rw=100 cl=1p
X_ID_02_05_500_05 vss ternary_case ip=0.2m pw=0.5n rw=500 cl=0.5p
X_ID_02_05_500_10 vss ternary_case ip=0.2m pw=0.5n rw=500 cl=1p
X_ID_02_10_100_05 vss ternary_case ip=0.2m pw=1n rw=100 cl=0.5p
X_ID_02_10_100_10 vss ternary_case ip=0.2m pw=1n rw=100 cl=1p
X_ID_02_10_500_05 vss ternary_case ip=0.2m pw=1n rw=500 cl=0.5p
X_ID_02_10_500_10 vss ternary_case ip=0.2m pw=1n rw=500 cl=1p
X_ID_02_30_100_05 vss ternary_case ip=0.2m pw=3n rw=100 cl=0.5p
X_ID_02_30_100_10 vss ternary_case ip=0.2m pw=3n rw=100 cl=1p
X_ID_02_30_500_05 vss ternary_case ip=0.2m pw=3n rw=500 cl=0.5p
X_ID_02_30_500_10 vss ternary_case ip=0.2m pw=3n rw=500 cl=1p
X_ID_02_100_100_05 vss ternary_case ip=0.2m pw=10n rw=100 cl=0.5p
X_ID_02_100_100_10 vss ternary_case ip=0.2m pw=10n rw=100 cl=1p
X_ID_02_100_500_05 vss ternary_case ip=0.2m pw=10n rw=500 cl=0.5p
X_ID_02_100_500_10 vss ternary_case ip=0.2m pw=10n rw=500 cl=1p
X_ID_05_05_100_05 vss ternary_case ip=0.5m pw=0.5n rw=100 cl=0.5p
X_ID_05_05_100_10 vss ternary_case ip=0.5m pw=0.5n rw=100 cl=1p
X_ID_05_05_500_05 vss ternary_case ip=0.5m pw=0.5n rw=500 cl=0.5p
X_ID_05_05_500_10 vss ternary_case ip=0.5m pw=0.5n rw=500 cl=1p
X_ID_05_10_100_05 vss ternary_case ip=0.5m pw=1n rw=100 cl=0.5p
X_ID_05_10_100_10 vss ternary_case ip=0.5m pw=1n rw=100 cl=1p
X_ID_05_10_500_05 vss ternary_case ip=0.5m pw=1n rw=500 cl=0.5p
X_ID_05_10_500_10 vss ternary_case ip=0.5m pw=1n rw=500 cl=1p
X_ID_05_30_100_05 vss ternary_case ip=0.5m pw=3n rw=100 cl=0.5p
X_ID_05_30_100_10 vss ternary_case ip=0.5m pw=3n rw=100 cl=1p
X_ID_05_30_500_05 vss ternary_case ip=0.5m pw=3n rw=500 cl=0.5p
X_ID_05_30_500_10 vss ternary_case ip=0.5m pw=3n rw=500 cl=1p
X_ID_05_100_100_05 vss ternary_case ip=0.5m pw=10n rw=100 cl=0.5p
X_ID_05_100_100_10 vss ternary_case ip=0.5m pw=10n rw=100 cl=1p
X_ID_05_100_500_05 vss ternary_case ip=0.5m pw=10n rw=500 cl=0.5p
X_ID_05_100_500_10 vss ternary_case ip=0.5m pw=10n rw=500 cl=1p
X_ID_10_05_100_05 vss ternary_case ip=1m pw=0.5n rw=100 cl=0.5p
X_ID_10_05_100_10 vss ternary_case ip=1m pw=0.5n rw=100 cl=1p
X_ID_10_05_500_05 vss ternary_case ip=1m pw=0.5n rw=500 cl=0.5p
X_ID_10_05_500_10 vss ternary_case ip=1m pw=0.5n rw=500 cl=1p
X_ID_10_10_100_05 vss ternary_case ip=1m pw=1n rw=100 cl=0.5p
X_ID_10_10_100_10 vss ternary_case ip=1m pw=1n rw=100 cl=1p
X_ID_10_10_500_05 vss ternary_case ip=1m pw=1n rw=500 cl=0.5p
X_ID_10_10_500_10 vss ternary_case ip=1m pw=1n rw=500 cl=1p
X_ID_10_30_100_05 vss ternary_case ip=1m pw=3n rw=100 cl=0.5p
X_ID_10_30_100_10 vss ternary_case ip=1m pw=3n rw=100 cl=1p
X_ID_10_30_500_05 vss ternary_case ip=1m pw=3n rw=500 cl=0.5p
X_ID_10_30_500_10 vss ternary_case ip=1m pw=3n rw=500 cl=1p
X_ID_10_100_100_05 vss ternary_case ip=1m pw=10n rw=100 cl=0.5p
X_ID_10_100_100_10 vss ternary_case ip=1m pw=10n rw=100 cl=1p
X_ID_10_100_500_05 vss ternary_case ip=1m pw=10n rw=500 cl=0.5p
X_ID_10_100_500_10 vss ternary_case ip=1m pw=10n rw=500 cl=1p
X_SC_02_05_100_05 vss ternary_case_s ip=0.2m pw=0.5n rw=100 cl=0.5p
X_SC_02_05_100_10 vss ternary_case_s ip=0.2m pw=0.5n rw=100 cl=1p
X_SC_02_05_500_05 vss ternary_case_s ip=0.2m pw=0.5n rw=500 cl=0.5p
X_SC_02_05_500_10 vss ternary_case_s ip=0.2m pw=0.5n rw=500 cl=1p
X_SC_02_10_100_05 vss ternary_case_s ip=0.2m pw=1n rw=100 cl=0.5p
X_SC_02_10_100_10 vss ternary_case_s ip=0.2m pw=1n rw=100 cl=1p
X_SC_02_10_500_05 vss ternary_case_s ip=0.2m pw=1n rw=500 cl=0.5p
X_SC_02_10_500_10 vss ternary_case_s ip=0.2m pw=1n rw=500 cl=1p
X_SC_02_30_100_05 vss ternary_case_s ip=0.2m pw=3n rw=100 cl=0.5p
X_SC_02_30_100_10 vss ternary_case_s ip=0.2m pw=3n rw=100 cl=1p
X_SC_02_30_500_05 vss ternary_case_s ip=0.2m pw=3n rw=500 cl=0.5p
X_SC_02_30_500_10 vss ternary_case_s ip=0.2m pw=3n rw=500 cl=1p
X_SC_02_100_100_05 vss ternary_case_s ip=0.2m pw=10n rw=100 cl=0.5p
X_SC_02_100_100_10 vss ternary_case_s ip=0.2m pw=10n rw=100 cl=1p
X_SC_02_100_500_05 vss ternary_case_s ip=0.2m pw=10n rw=500 cl=0.5p
X_SC_02_100_500_10 vss ternary_case_s ip=0.2m pw=10n rw=500 cl=1p
X_SC_05_05_100_05 vss ternary_case_s ip=0.5m pw=0.5n rw=100 cl=0.5p
X_SC_05_05_100_10 vss ternary_case_s ip=0.5m pw=0.5n rw=100 cl=1p
X_SC_05_05_500_05 vss ternary_case_s ip=0.5m pw=0.5n rw=500 cl=0.5p
X_SC_05_05_500_10 vss ternary_case_s ip=0.5m pw=0.5n rw=500 cl=1p
X_SC_05_10_100_05 vss ternary_case_s ip=0.5m pw=1n rw=100 cl=0.5p
X_SC_05_10_100_10 vss ternary_case_s ip=0.5m pw=1n rw=100 cl=1p
X_SC_05_10_500_05 vss ternary_case_s ip=0.5m pw=1n rw=500 cl=0.5p
X_SC_05_10_500_10 vss ternary_case_s ip=0.5m pw=1n rw=500 cl=1p
X_SC_05_30_100_05 vss ternary_case_s ip=0.5m pw=3n rw=100 cl=0.5p
X_SC_05_30_100_10 vss ternary_case_s ip=0.5m pw=3n rw=100 cl=1p
X_SC_05_30_500_05 vss ternary_case_s ip=0.5m pw=3n rw=500 cl=0.5p
X_SC_05_30_500_10 vss ternary_case_s ip=0.5m pw=3n rw=500 cl=1p
X_SC_05_100_100_05 vss ternary_case_s ip=0.5m pw=10n rw=100 cl=0.5p
X_SC_05_100_100_10 vss ternary_case_s ip=0.5m pw=10n rw=100 cl=1p
X_SC_05_100_500_05 vss ternary_case_s ip=0.5m pw=10n rw=500 cl=0.5p
X_SC_05_100_500_10 vss ternary_case_s ip=0.5m pw=10n rw=500 cl=1p
X_SC_10_05_100_05 vss ternary_case_s ip=1m pw=0.5n rw=100 cl=0.5p
X_SC_10_05_100_10 vss ternary_case_s ip=1m pw=0.5n rw=100 cl=1p
X_SC_10_05_500_05 vss ternary_case_s ip=1m pw=0.5n rw=500 cl=0.5p
X_SC_10_05_500_10 vss ternary_case_s ip=1m pw=0.5n rw=500 cl=1p
X_SC_10_10_100_05 vss ternary_case_s ip=1m pw=1n rw=100 cl=0.5p
X_SC_10_10_100_10 vss ternary_case_s ip=1m pw=1n rw=100 cl=1p
X_SC_10_10_500_05 vss ternary_case_s ip=1m pw=1n rw=500 cl=0.5p
X_SC_10_10_500_10 vss ternary_case_s ip=1m pw=1n rw=500 cl=1p
X_SC_10_30_100_05 vss ternary_case_s ip=1m pw=3n rw=100 cl=0.5p
X_SC_10_30_100_10 vss ternary_case_s ip=1m pw=3n rw=100 cl=1p
X_SC_10_30_500_05 vss ternary_case_s ip=1m pw=3n rw=500 cl=0.5p
X_SC_10_30_500_10 vss ternary_case_s ip=1m pw=3n rw=500 cl=1p
X_SC_10_100_100_05 vss ternary_case_s ip=1m pw=10n rw=100 cl=0.5p
X_SC_10_100_100_10 vss ternary_case_s ip=1m pw=10n rw=100 cl=1p
X_SC_10_100_500_05 vss ternary_case_s ip=1m pw=10n rw=500 cl=0.5p
X_SC_10_100_500_10 vss ternary_case_s ip=1m pw=10n rw=500 cl=1p

* ---------- global null case (idle driver, fixed) ----------
In 0 dN DC 0
RidleN dN 0 10meg
VsN dN drvN DC 0
RwN drvN xN 500
CxN xN 0 1p
RtermN xN 0 1meg
D1N xN rAn DIDEAL
D2N rBn xN DIDEAL
RLAN rAn 0 500
CLAN rAn 0 0.2p
RLBN rBn 0 500
CLBN rBn 0 0.2p
BpN pwpN 0 V = V(drvN)*I(VsN)

.tran 100p 200n

* ---------- measurements: 8 per instance ----------
.meas tran epush_X_ID_02_05_100_05 INTEG V(X_ID_02_05_100_05.pwpA) FROM=9n TO=26n
.meas tran epull_X_ID_02_05_100_05 INTEG V(X_ID_02_05_100_05.pwpB) FROM=39n TO=56n
.meas tran ecyc1_X_ID_02_05_100_05 INTEG V(X_ID_02_05_100_05.pwpC) FROM=99n TO=123n
.meas tran ecyc2_X_ID_02_05_100_05 INTEG V(X_ID_02_05_100_05.pwpC) FROM=123n TO=139n
.meas tran ecycT_X_ID_02_05_100_05 INTEG V(X_ID_02_05_100_05.pwpC) FROM=99n TO=139n
.meas tran vraA_X_ID_02_05_100_05 MAX V(X_ID_02_05_100_05.rAp) FROM=9n TO=26n
.meas tran vraB_X_ID_02_05_100_05 MIN V(X_ID_02_05_100_05.rBq) FROM=39n TO=56n
.meas tran vlnA_X_ID_02_05_100_05 MAX V(X_ID_02_05_100_05.drvA) FROM=9n TO=26n
.meas tran epush_X_ID_02_05_100_10 INTEG V(X_ID_02_05_100_10.pwpA) FROM=9n TO=26n
.meas tran epull_X_ID_02_05_100_10 INTEG V(X_ID_02_05_100_10.pwpB) FROM=39n TO=56n
.meas tran ecyc1_X_ID_02_05_100_10 INTEG V(X_ID_02_05_100_10.pwpC) FROM=99n TO=123n
.meas tran ecyc2_X_ID_02_05_100_10 INTEG V(X_ID_02_05_100_10.pwpC) FROM=123n TO=139n
.meas tran ecycT_X_ID_02_05_100_10 INTEG V(X_ID_02_05_100_10.pwpC) FROM=99n TO=139n
.meas tran vraA_X_ID_02_05_100_10 MAX V(X_ID_02_05_100_10.rAp) FROM=9n TO=26n
.meas tran vraB_X_ID_02_05_100_10 MIN V(X_ID_02_05_100_10.rBq) FROM=39n TO=56n
.meas tran vlnA_X_ID_02_05_100_10 MAX V(X_ID_02_05_100_10.drvA) FROM=9n TO=26n
.meas tran epush_X_ID_02_05_500_05 INTEG V(X_ID_02_05_500_05.pwpA) FROM=9n TO=26n
.meas tran epull_X_ID_02_05_500_05 INTEG V(X_ID_02_05_500_05.pwpB) FROM=39n TO=56n
.meas tran ecyc1_X_ID_02_05_500_05 INTEG V(X_ID_02_05_500_05.pwpC) FROM=99n TO=123n
.meas tran ecyc2_X_ID_02_05_500_05 INTEG V(X_ID_02_05_500_05.pwpC) FROM=123n TO=139n
.meas tran ecycT_X_ID_02_05_500_05 INTEG V(X_ID_02_05_500_05.pwpC) FROM=99n TO=139n
.meas tran vraA_X_ID_02_05_500_05 MAX V(X_ID_02_05_500_05.rAp) FROM=9n TO=26n
.meas tran vraB_X_ID_02_05_500_05 MIN V(X_ID_02_05_500_05.rBq) FROM=39n TO=56n
.meas tran vlnA_X_ID_02_05_500_05 MAX V(X_ID_02_05_500_05.drvA) FROM=9n TO=26n
.meas tran epush_X_ID_02_05_500_10 INTEG V(X_ID_02_05_500_10.pwpA) FROM=9n TO=26n
.meas tran epull_X_ID_02_05_500_10 INTEG V(X_ID_02_05_500_10.pwpB) FROM=39n TO=56n
.meas tran ecyc1_X_ID_02_05_500_10 INTEG V(X_ID_02_05_500_10.pwpC) FROM=99n TO=123n
.meas tran ecyc2_X_ID_02_05_500_10 INTEG V(X_ID_02_05_500_10.pwpC) FROM=123n TO=139n
.meas tran ecycT_X_ID_02_05_500_10 INTEG V(X_ID_02_05_500_10.pwpC) FROM=99n TO=139n
.meas tran vraA_X_ID_02_05_500_10 MAX V(X_ID_02_05_500_10.rAp) FROM=9n TO=26n
.meas tran vraB_X_ID_02_05_500_10 MIN V(X_ID_02_05_500_10.rBq) FROM=39n TO=56n
.meas tran vlnA_X_ID_02_05_500_10 MAX V(X_ID_02_05_500_10.drvA) FROM=9n TO=26n
.meas tran epush_X_ID_02_10_100_05 INTEG V(X_ID_02_10_100_05.pwpA) FROM=9n TO=26n
.meas tran epull_X_ID_02_10_100_05 INTEG V(X_ID_02_10_100_05.pwpB) FROM=39n TO=56n
.meas tran ecyc1_X_ID_02_10_100_05 INTEG V(X_ID_02_10_100_05.pwpC) FROM=99n TO=123n
.meas tran ecyc2_X_ID_02_10_100_05 INTEG V(X_ID_02_10_100_05.pwpC) FROM=123n TO=139n
.meas tran ecycT_X_ID_02_10_100_05 INTEG V(X_ID_02_10_100_05.pwpC) FROM=99n TO=139n
.meas tran vraA_X_ID_02_10_100_05 MAX V(X_ID_02_10_100_05.rAp) FROM=9n TO=26n
.meas tran vraB_X_ID_02_10_100_05 MIN V(X_ID_02_10_100_05.rBq) FROM=39n TO=56n
.meas tran vlnA_X_ID_02_10_100_05 MAX V(X_ID_02_10_100_05.drvA) FROM=9n TO=26n
.meas tran epush_X_ID_02_10_100_10 INTEG V(X_ID_02_10_100_10.pwpA) FROM=9n TO=26n
.meas tran epull_X_ID_02_10_100_10 INTEG V(X_ID_02_10_100_10.pwpB) FROM=39n TO=56n
.meas tran ecyc1_X_ID_02_10_100_10 INTEG V(X_ID_02_10_100_10.pwpC) FROM=99n TO=123n
.meas tran ecyc2_X_ID_02_10_100_10 INTEG V(X_ID_02_10_100_10.pwpC) FROM=123n TO=139n
.meas tran ecycT_X_ID_02_10_100_10 INTEG V(X_ID_02_10_100_10.pwpC) FROM=99n TO=139n
.meas tran vraA_X_ID_02_10_100_10 MAX V(X_ID_02_10_100_10.rAp) FROM=9n TO=26n
.meas tran vraB_X_ID_02_10_100_10 MIN V(X_ID_02_10_100_10.rBq) FROM=39n TO=56n
.meas tran vlnA_X_ID_02_10_100_10 MAX V(X_ID_02_10_100_10.drvA) FROM=9n TO=26n
.meas tran epush_X_ID_02_10_500_05 INTEG V(X_ID_02_10_500_05.pwpA) FROM=9n TO=26n
.meas tran epull_X_ID_02_10_500_05 INTEG V(X_ID_02_10_500_05.pwpB) FROM=39n TO=56n
.meas tran ecyc1_X_ID_02_10_500_05 INTEG V(X_ID_02_10_500_05.pwpC) FROM=99n TO=123n
.meas tran ecyc2_X_ID_02_10_500_05 INTEG V(X_ID_02_10_500_05.pwpC) FROM=123n TO=139n
.meas tran ecycT_X_ID_02_10_500_05 INTEG V(X_ID_02_10_500_05.pwpC) FROM=99n TO=139n
.meas tran vraA_X_ID_02_10_500_05 MAX V(X_ID_02_10_500_05.rAp) FROM=9n TO=26n
.meas tran vraB_X_ID_02_10_500_05 MIN V(X_ID_02_10_500_05.rBq) FROM=39n TO=56n
.meas tran vlnA_X_ID_02_10_500_05 MAX V(X_ID_02_10_500_05.drvA) FROM=9n TO=26n
.meas tran epush_X_ID_02_10_500_10 INTEG V(X_ID_02_10_500_10.pwpA) FROM=9n TO=26n
.meas tran epull_X_ID_02_10_500_10 INTEG V(X_ID_02_10_500_10.pwpB) FROM=39n TO=56n
.meas tran ecyc1_X_ID_02_10_500_10 INTEG V(X_ID_02_10_500_10.pwpC) FROM=99n TO=123n
.meas tran ecyc2_X_ID_02_10_500_10 INTEG V(X_ID_02_10_500_10.pwpC) FROM=123n TO=139n
.meas tran ecycT_X_ID_02_10_500_10 INTEG V(X_ID_02_10_500_10.pwpC) FROM=99n TO=139n
.meas tran vraA_X_ID_02_10_500_10 MAX V(X_ID_02_10_500_10.rAp) FROM=9n TO=26n
.meas tran vraB_X_ID_02_10_500_10 MIN V(X_ID_02_10_500_10.rBq) FROM=39n TO=56n
.meas tran vlnA_X_ID_02_10_500_10 MAX V(X_ID_02_10_500_10.drvA) FROM=9n TO=26n
.meas tran epush_X_ID_02_30_100_05 INTEG V(X_ID_02_30_100_05.pwpA) FROM=9n TO=26n
.meas tran epull_X_ID_02_30_100_05 INTEG V(X_ID_02_30_100_05.pwpB) FROM=39n TO=56n
.meas tran ecyc1_X_ID_02_30_100_05 INTEG V(X_ID_02_30_100_05.pwpC) FROM=99n TO=123n
.meas tran ecyc2_X_ID_02_30_100_05 INTEG V(X_ID_02_30_100_05.pwpC) FROM=123n TO=139n
.meas tran ecycT_X_ID_02_30_100_05 INTEG V(X_ID_02_30_100_05.pwpC) FROM=99n TO=139n
.meas tran vraA_X_ID_02_30_100_05 MAX V(X_ID_02_30_100_05.rAp) FROM=9n TO=26n
.meas tran vraB_X_ID_02_30_100_05 MIN V(X_ID_02_30_100_05.rBq) FROM=39n TO=56n
.meas tran vlnA_X_ID_02_30_100_05 MAX V(X_ID_02_30_100_05.drvA) FROM=9n TO=26n
.meas tran epush_X_ID_02_30_100_10 INTEG V(X_ID_02_30_100_10.pwpA) FROM=9n TO=26n
.meas tran epull_X_ID_02_30_100_10 INTEG V(X_ID_02_30_100_10.pwpB) FROM=39n TO=56n
.meas tran ecyc1_X_ID_02_30_100_10 INTEG V(X_ID_02_30_100_10.pwpC) FROM=99n TO=123n
.meas tran ecyc2_X_ID_02_30_100_10 INTEG V(X_ID_02_30_100_10.pwpC) FROM=123n TO=139n
.meas tran ecycT_X_ID_02_30_100_10 INTEG V(X_ID_02_30_100_10.pwpC) FROM=99n TO=139n
.meas tran vraA_X_ID_02_30_100_10 MAX V(X_ID_02_30_100_10.rAp) FROM=9n TO=26n
.meas tran vraB_X_ID_02_30_100_10 MIN V(X_ID_02_30_100_10.rBq) FROM=39n TO=56n
.meas tran vlnA_X_ID_02_30_100_10 MAX V(X_ID_02_30_100_10.drvA) FROM=9n TO=26n
.meas tran epush_X_ID_02_30_500_05 INTEG V(X_ID_02_30_500_05.pwpA) FROM=9n TO=26n
.meas tran epull_X_ID_02_30_500_05 INTEG V(X_ID_02_30_500_05.pwpB) FROM=39n TO=56n
.meas tran ecyc1_X_ID_02_30_500_05 INTEG V(X_ID_02_30_500_05.pwpC) FROM=99n TO=123n
.meas tran ecyc2_X_ID_02_30_500_05 INTEG V(X_ID_02_30_500_05.pwpC) FROM=123n TO=139n
.meas tran ecycT_X_ID_02_30_500_05 INTEG V(X_ID_02_30_500_05.pwpC) FROM=99n TO=139n
.meas tran vraA_X_ID_02_30_500_05 MAX V(X_ID_02_30_500_05.rAp) FROM=9n TO=26n
.meas tran vraB_X_ID_02_30_500_05 MIN V(X_ID_02_30_500_05.rBq) FROM=39n TO=56n
.meas tran vlnA_X_ID_02_30_500_05 MAX V(X_ID_02_30_500_05.drvA) FROM=9n TO=26n
.meas tran epush_X_ID_02_30_500_10 INTEG V(X_ID_02_30_500_10.pwpA) FROM=9n TO=26n
.meas tran epull_X_ID_02_30_500_10 INTEG V(X_ID_02_30_500_10.pwpB) FROM=39n TO=56n
.meas tran ecyc1_X_ID_02_30_500_10 INTEG V(X_ID_02_30_500_10.pwpC) FROM=99n TO=123n
.meas tran ecyc2_X_ID_02_30_500_10 INTEG V(X_ID_02_30_500_10.pwpC) FROM=123n TO=139n
.meas tran ecycT_X_ID_02_30_500_10 INTEG V(X_ID_02_30_500_10.pwpC) FROM=99n TO=139n
.meas tran vraA_X_ID_02_30_500_10 MAX V(X_ID_02_30_500_10.rAp) FROM=9n TO=26n
.meas tran vraB_X_ID_02_30_500_10 MIN V(X_ID_02_30_500_10.rBq) FROM=39n TO=56n
.meas tran vlnA_X_ID_02_30_500_10 MAX V(X_ID_02_30_500_10.drvA) FROM=9n TO=26n
.meas tran epush_X_ID_02_100_100_05 INTEG V(X_ID_02_100_100_05.pwpA) FROM=9n TO=26n
.meas tran epull_X_ID_02_100_100_05 INTEG V(X_ID_02_100_100_05.pwpB) FROM=39n TO=56n
.meas tran ecyc1_X_ID_02_100_100_05 INTEG V(X_ID_02_100_100_05.pwpC) FROM=99n TO=123n
.meas tran ecyc2_X_ID_02_100_100_05 INTEG V(X_ID_02_100_100_05.pwpC) FROM=123n TO=139n
.meas tran ecycT_X_ID_02_100_100_05 INTEG V(X_ID_02_100_100_05.pwpC) FROM=99n TO=139n
.meas tran vraA_X_ID_02_100_100_05 MAX V(X_ID_02_100_100_05.rAp) FROM=9n TO=26n
.meas tran vraB_X_ID_02_100_100_05 MIN V(X_ID_02_100_100_05.rBq) FROM=39n TO=56n
.meas tran vlnA_X_ID_02_100_100_05 MAX V(X_ID_02_100_100_05.drvA) FROM=9n TO=26n
.meas tran epush_X_ID_02_100_100_10 INTEG V(X_ID_02_100_100_10.pwpA) FROM=9n TO=26n
.meas tran epull_X_ID_02_100_100_10 INTEG V(X_ID_02_100_100_10.pwpB) FROM=39n TO=56n
.meas tran ecyc1_X_ID_02_100_100_10 INTEG V(X_ID_02_100_100_10.pwpC) FROM=99n TO=123n
.meas tran ecyc2_X_ID_02_100_100_10 INTEG V(X_ID_02_100_100_10.pwpC) FROM=123n TO=139n
.meas tran ecycT_X_ID_02_100_100_10 INTEG V(X_ID_02_100_100_10.pwpC) FROM=99n TO=139n
.meas tran vraA_X_ID_02_100_100_10 MAX V(X_ID_02_100_100_10.rAp) FROM=9n TO=26n
.meas tran vraB_X_ID_02_100_100_10 MIN V(X_ID_02_100_100_10.rBq) FROM=39n TO=56n
.meas tran vlnA_X_ID_02_100_100_10 MAX V(X_ID_02_100_100_10.drvA) FROM=9n TO=26n
.meas tran epush_X_ID_02_100_500_05 INTEG V(X_ID_02_100_500_05.pwpA) FROM=9n TO=26n
.meas tran epull_X_ID_02_100_500_05 INTEG V(X_ID_02_100_500_05.pwpB) FROM=39n TO=56n
.meas tran ecyc1_X_ID_02_100_500_05 INTEG V(X_ID_02_100_500_05.pwpC) FROM=99n TO=123n
.meas tran ecyc2_X_ID_02_100_500_05 INTEG V(X_ID_02_100_500_05.pwpC) FROM=123n TO=139n
.meas tran ecycT_X_ID_02_100_500_05 INTEG V(X_ID_02_100_500_05.pwpC) FROM=99n TO=139n
.meas tran vraA_X_ID_02_100_500_05 MAX V(X_ID_02_100_500_05.rAp) FROM=9n TO=26n
.meas tran vraB_X_ID_02_100_500_05 MIN V(X_ID_02_100_500_05.rBq) FROM=39n TO=56n
.meas tran vlnA_X_ID_02_100_500_05 MAX V(X_ID_02_100_500_05.drvA) FROM=9n TO=26n
.meas tran epush_X_ID_02_100_500_10 INTEG V(X_ID_02_100_500_10.pwpA) FROM=9n TO=26n
.meas tran epull_X_ID_02_100_500_10 INTEG V(X_ID_02_100_500_10.pwpB) FROM=39n TO=56n
.meas tran ecyc1_X_ID_02_100_500_10 INTEG V(X_ID_02_100_500_10.pwpC) FROM=99n TO=123n
.meas tran ecyc2_X_ID_02_100_500_10 INTEG V(X_ID_02_100_500_10.pwpC) FROM=123n TO=139n
.meas tran ecycT_X_ID_02_100_500_10 INTEG V(X_ID_02_100_500_10.pwpC) FROM=99n TO=139n
.meas tran vraA_X_ID_02_100_500_10 MAX V(X_ID_02_100_500_10.rAp) FROM=9n TO=26n
.meas tran vraB_X_ID_02_100_500_10 MIN V(X_ID_02_100_500_10.rBq) FROM=39n TO=56n
.meas tran vlnA_X_ID_02_100_500_10 MAX V(X_ID_02_100_500_10.drvA) FROM=9n TO=26n
.meas tran epush_X_ID_05_05_100_05 INTEG V(X_ID_05_05_100_05.pwpA) FROM=9n TO=26n
.meas tran epull_X_ID_05_05_100_05 INTEG V(X_ID_05_05_100_05.pwpB) FROM=39n TO=56n
.meas tran ecyc1_X_ID_05_05_100_05 INTEG V(X_ID_05_05_100_05.pwpC) FROM=99n TO=123n
.meas tran ecyc2_X_ID_05_05_100_05 INTEG V(X_ID_05_05_100_05.pwpC) FROM=123n TO=139n
.meas tran ecycT_X_ID_05_05_100_05 INTEG V(X_ID_05_05_100_05.pwpC) FROM=99n TO=139n
.meas tran vraA_X_ID_05_05_100_05 MAX V(X_ID_05_05_100_05.rAp) FROM=9n TO=26n
.meas tran vraB_X_ID_05_05_100_05 MIN V(X_ID_05_05_100_05.rBq) FROM=39n TO=56n
.meas tran vlnA_X_ID_05_05_100_05 MAX V(X_ID_05_05_100_05.drvA) FROM=9n TO=26n
.meas tran epush_X_ID_05_05_100_10 INTEG V(X_ID_05_05_100_10.pwpA) FROM=9n TO=26n
.meas tran epull_X_ID_05_05_100_10 INTEG V(X_ID_05_05_100_10.pwpB) FROM=39n TO=56n
.meas tran ecyc1_X_ID_05_05_100_10 INTEG V(X_ID_05_05_100_10.pwpC) FROM=99n TO=123n
.meas tran ecyc2_X_ID_05_05_100_10 INTEG V(X_ID_05_05_100_10.pwpC) FROM=123n TO=139n
.meas tran ecycT_X_ID_05_05_100_10 INTEG V(X_ID_05_05_100_10.pwpC) FROM=99n TO=139n
.meas tran vraA_X_ID_05_05_100_10 MAX V(X_ID_05_05_100_10.rAp) FROM=9n TO=26n
.meas tran vraB_X_ID_05_05_100_10 MIN V(X_ID_05_05_100_10.rBq) FROM=39n TO=56n
.meas tran vlnA_X_ID_05_05_100_10 MAX V(X_ID_05_05_100_10.drvA) FROM=9n TO=26n
.meas tran epush_X_ID_05_05_500_05 INTEG V(X_ID_05_05_500_05.pwpA) FROM=9n TO=26n
.meas tran epull_X_ID_05_05_500_05 INTEG V(X_ID_05_05_500_05.pwpB) FROM=39n TO=56n
.meas tran ecyc1_X_ID_05_05_500_05 INTEG V(X_ID_05_05_500_05.pwpC) FROM=99n TO=123n
.meas tran ecyc2_X_ID_05_05_500_05 INTEG V(X_ID_05_05_500_05.pwpC) FROM=123n TO=139n
.meas tran ecycT_X_ID_05_05_500_05 INTEG V(X_ID_05_05_500_05.pwpC) FROM=99n TO=139n
.meas tran vraA_X_ID_05_05_500_05 MAX V(X_ID_05_05_500_05.rAp) FROM=9n TO=26n
.meas tran vraB_X_ID_05_05_500_05 MIN V(X_ID_05_05_500_05.rBq) FROM=39n TO=56n
.meas tran vlnA_X_ID_05_05_500_05 MAX V(X_ID_05_05_500_05.drvA) FROM=9n TO=26n
.meas tran epush_X_ID_05_05_500_10 INTEG V(X_ID_05_05_500_10.pwpA) FROM=9n TO=26n
.meas tran epull_X_ID_05_05_500_10 INTEG V(X_ID_05_05_500_10.pwpB) FROM=39n TO=56n
.meas tran ecyc1_X_ID_05_05_500_10 INTEG V(X_ID_05_05_500_10.pwpC) FROM=99n TO=123n
.meas tran ecyc2_X_ID_05_05_500_10 INTEG V(X_ID_05_05_500_10.pwpC) FROM=123n TO=139n
.meas tran ecycT_X_ID_05_05_500_10 INTEG V(X_ID_05_05_500_10.pwpC) FROM=99n TO=139n
.meas tran vraA_X_ID_05_05_500_10 MAX V(X_ID_05_05_500_10.rAp) FROM=9n TO=26n
.meas tran vraB_X_ID_05_05_500_10 MIN V(X_ID_05_05_500_10.rBq) FROM=39n TO=56n
.meas tran vlnA_X_ID_05_05_500_10 MAX V(X_ID_05_05_500_10.drvA) FROM=9n TO=26n
.meas tran epush_X_ID_05_10_100_05 INTEG V(X_ID_05_10_100_05.pwpA) FROM=9n TO=26n
.meas tran epull_X_ID_05_10_100_05 INTEG V(X_ID_05_10_100_05.pwpB) FROM=39n TO=56n
.meas tran ecyc1_X_ID_05_10_100_05 INTEG V(X_ID_05_10_100_05.pwpC) FROM=99n TO=123n
.meas tran ecyc2_X_ID_05_10_100_05 INTEG V(X_ID_05_10_100_05.pwpC) FROM=123n TO=139n
.meas tran ecycT_X_ID_05_10_100_05 INTEG V(X_ID_05_10_100_05.pwpC) FROM=99n TO=139n
.meas tran vraA_X_ID_05_10_100_05 MAX V(X_ID_05_10_100_05.rAp) FROM=9n TO=26n
.meas tran vraB_X_ID_05_10_100_05 MIN V(X_ID_05_10_100_05.rBq) FROM=39n TO=56n
.meas tran vlnA_X_ID_05_10_100_05 MAX V(X_ID_05_10_100_05.drvA) FROM=9n TO=26n
.meas tran epush_X_ID_05_10_100_10 INTEG V(X_ID_05_10_100_10.pwpA) FROM=9n TO=26n
.meas tran epull_X_ID_05_10_100_10 INTEG V(X_ID_05_10_100_10.pwpB) FROM=39n TO=56n
.meas tran ecyc1_X_ID_05_10_100_10 INTEG V(X_ID_05_10_100_10.pwpC) FROM=99n TO=123n
.meas tran ecyc2_X_ID_05_10_100_10 INTEG V(X_ID_05_10_100_10.pwpC) FROM=123n TO=139n
.meas tran ecycT_X_ID_05_10_100_10 INTEG V(X_ID_05_10_100_10.pwpC) FROM=99n TO=139n
.meas tran vraA_X_ID_05_10_100_10 MAX V(X_ID_05_10_100_10.rAp) FROM=9n TO=26n
.meas tran vraB_X_ID_05_10_100_10 MIN V(X_ID_05_10_100_10.rBq) FROM=39n TO=56n
.meas tran vlnA_X_ID_05_10_100_10 MAX V(X_ID_05_10_100_10.drvA) FROM=9n TO=26n
.meas tran epush_X_ID_05_10_500_05 INTEG V(X_ID_05_10_500_05.pwpA) FROM=9n TO=26n
.meas tran epull_X_ID_05_10_500_05 INTEG V(X_ID_05_10_500_05.pwpB) FROM=39n TO=56n
.meas tran ecyc1_X_ID_05_10_500_05 INTEG V(X_ID_05_10_500_05.pwpC) FROM=99n TO=123n
.meas tran ecyc2_X_ID_05_10_500_05 INTEG V(X_ID_05_10_500_05.pwpC) FROM=123n TO=139n
.meas tran ecycT_X_ID_05_10_500_05 INTEG V(X_ID_05_10_500_05.pwpC) FROM=99n TO=139n
.meas tran vraA_X_ID_05_10_500_05 MAX V(X_ID_05_10_500_05.rAp) FROM=9n TO=26n
.meas tran vraB_X_ID_05_10_500_05 MIN V(X_ID_05_10_500_05.rBq) FROM=39n TO=56n
.meas tran vlnA_X_ID_05_10_500_05 MAX V(X_ID_05_10_500_05.drvA) FROM=9n TO=26n
.meas tran epush_X_ID_05_10_500_10 INTEG V(X_ID_05_10_500_10.pwpA) FROM=9n TO=26n
.meas tran epull_X_ID_05_10_500_10 INTEG V(X_ID_05_10_500_10.pwpB) FROM=39n TO=56n
.meas tran ecyc1_X_ID_05_10_500_10 INTEG V(X_ID_05_10_500_10.pwpC) FROM=99n TO=123n
.meas tran ecyc2_X_ID_05_10_500_10 INTEG V(X_ID_05_10_500_10.pwpC) FROM=123n TO=139n
.meas tran ecycT_X_ID_05_10_500_10 INTEG V(X_ID_05_10_500_10.pwpC) FROM=99n TO=139n
.meas tran vraA_X_ID_05_10_500_10 MAX V(X_ID_05_10_500_10.rAp) FROM=9n TO=26n
.meas tran vraB_X_ID_05_10_500_10 MIN V(X_ID_05_10_500_10.rBq) FROM=39n TO=56n
.meas tran vlnA_X_ID_05_10_500_10 MAX V(X_ID_05_10_500_10.drvA) FROM=9n TO=26n
.meas tran epush_X_ID_05_30_100_05 INTEG V(X_ID_05_30_100_05.pwpA) FROM=9n TO=26n
.meas tran epull_X_ID_05_30_100_05 INTEG V(X_ID_05_30_100_05.pwpB) FROM=39n TO=56n
.meas tran ecyc1_X_ID_05_30_100_05 INTEG V(X_ID_05_30_100_05.pwpC) FROM=99n TO=123n
.meas tran ecyc2_X_ID_05_30_100_05 INTEG V(X_ID_05_30_100_05.pwpC) FROM=123n TO=139n
.meas tran ecycT_X_ID_05_30_100_05 INTEG V(X_ID_05_30_100_05.pwpC) FROM=99n TO=139n
.meas tran vraA_X_ID_05_30_100_05 MAX V(X_ID_05_30_100_05.rAp) FROM=9n TO=26n
.meas tran vraB_X_ID_05_30_100_05 MIN V(X_ID_05_30_100_05.rBq) FROM=39n TO=56n
.meas tran vlnA_X_ID_05_30_100_05 MAX V(X_ID_05_30_100_05.drvA) FROM=9n TO=26n
.meas tran epush_X_ID_05_30_100_10 INTEG V(X_ID_05_30_100_10.pwpA) FROM=9n TO=26n
.meas tran epull_X_ID_05_30_100_10 INTEG V(X_ID_05_30_100_10.pwpB) FROM=39n TO=56n
.meas tran ecyc1_X_ID_05_30_100_10 INTEG V(X_ID_05_30_100_10.pwpC) FROM=99n TO=123n
.meas tran ecyc2_X_ID_05_30_100_10 INTEG V(X_ID_05_30_100_10.pwpC) FROM=123n TO=139n
.meas tran ecycT_X_ID_05_30_100_10 INTEG V(X_ID_05_30_100_10.pwpC) FROM=99n TO=139n
.meas tran vraA_X_ID_05_30_100_10 MAX V(X_ID_05_30_100_10.rAp) FROM=9n TO=26n
.meas tran vraB_X_ID_05_30_100_10 MIN V(X_ID_05_30_100_10.rBq) FROM=39n TO=56n
.meas tran vlnA_X_ID_05_30_100_10 MAX V(X_ID_05_30_100_10.drvA) FROM=9n TO=26n
.meas tran epush_X_ID_05_30_500_05 INTEG V(X_ID_05_30_500_05.pwpA) FROM=9n TO=26n
.meas tran epull_X_ID_05_30_500_05 INTEG V(X_ID_05_30_500_05.pwpB) FROM=39n TO=56n
.meas tran ecyc1_X_ID_05_30_500_05 INTEG V(X_ID_05_30_500_05.pwpC) FROM=99n TO=123n
.meas tran ecyc2_X_ID_05_30_500_05 INTEG V(X_ID_05_30_500_05.pwpC) FROM=123n TO=139n
.meas tran ecycT_X_ID_05_30_500_05 INTEG V(X_ID_05_30_500_05.pwpC) FROM=99n TO=139n
.meas tran vraA_X_ID_05_30_500_05 MAX V(X_ID_05_30_500_05.rAp) FROM=9n TO=26n
.meas tran vraB_X_ID_05_30_500_05 MIN V(X_ID_05_30_500_05.rBq) FROM=39n TO=56n
.meas tran vlnA_X_ID_05_30_500_05 MAX V(X_ID_05_30_500_05.drvA) FROM=9n TO=26n
.meas tran epush_X_ID_05_30_500_10 INTEG V(X_ID_05_30_500_10.pwpA) FROM=9n TO=26n
.meas tran epull_X_ID_05_30_500_10 INTEG V(X_ID_05_30_500_10.pwpB) FROM=39n TO=56n
.meas tran ecyc1_X_ID_05_30_500_10 INTEG V(X_ID_05_30_500_10.pwpC) FROM=99n TO=123n
.meas tran ecyc2_X_ID_05_30_500_10 INTEG V(X_ID_05_30_500_10.pwpC) FROM=123n TO=139n
.meas tran ecycT_X_ID_05_30_500_10 INTEG V(X_ID_05_30_500_10.pwpC) FROM=99n TO=139n
.meas tran vraA_X_ID_05_30_500_10 MAX V(X_ID_05_30_500_10.rAp) FROM=9n TO=26n
.meas tran vraB_X_ID_05_30_500_10 MIN V(X_ID_05_30_500_10.rBq) FROM=39n TO=56n
.meas tran vlnA_X_ID_05_30_500_10 MAX V(X_ID_05_30_500_10.drvA) FROM=9n TO=26n
.meas tran epush_X_ID_05_100_100_05 INTEG V(X_ID_05_100_100_05.pwpA) FROM=9n TO=26n
.meas tran epull_X_ID_05_100_100_05 INTEG V(X_ID_05_100_100_05.pwpB) FROM=39n TO=56n
.meas tran ecyc1_X_ID_05_100_100_05 INTEG V(X_ID_05_100_100_05.pwpC) FROM=99n TO=123n
.meas tran ecyc2_X_ID_05_100_100_05 INTEG V(X_ID_05_100_100_05.pwpC) FROM=123n TO=139n
.meas tran ecycT_X_ID_05_100_100_05 INTEG V(X_ID_05_100_100_05.pwpC) FROM=99n TO=139n
.meas tran vraA_X_ID_05_100_100_05 MAX V(X_ID_05_100_100_05.rAp) FROM=9n TO=26n
.meas tran vraB_X_ID_05_100_100_05 MIN V(X_ID_05_100_100_05.rBq) FROM=39n TO=56n
.meas tran vlnA_X_ID_05_100_100_05 MAX V(X_ID_05_100_100_05.drvA) FROM=9n TO=26n
.meas tran epush_X_ID_05_100_100_10 INTEG V(X_ID_05_100_100_10.pwpA) FROM=9n TO=26n
.meas tran epull_X_ID_05_100_100_10 INTEG V(X_ID_05_100_100_10.pwpB) FROM=39n TO=56n
.meas tran ecyc1_X_ID_05_100_100_10 INTEG V(X_ID_05_100_100_10.pwpC) FROM=99n TO=123n
.meas tran ecyc2_X_ID_05_100_100_10 INTEG V(X_ID_05_100_100_10.pwpC) FROM=123n TO=139n
.meas tran ecycT_X_ID_05_100_100_10 INTEG V(X_ID_05_100_100_10.pwpC) FROM=99n TO=139n
.meas tran vraA_X_ID_05_100_100_10 MAX V(X_ID_05_100_100_10.rAp) FROM=9n TO=26n
.meas tran vraB_X_ID_05_100_100_10 MIN V(X_ID_05_100_100_10.rBq) FROM=39n TO=56n
.meas tran vlnA_X_ID_05_100_100_10 MAX V(X_ID_05_100_100_10.drvA) FROM=9n TO=26n
.meas tran epush_X_ID_05_100_500_05 INTEG V(X_ID_05_100_500_05.pwpA) FROM=9n TO=26n
.meas tran epull_X_ID_05_100_500_05 INTEG V(X_ID_05_100_500_05.pwpB) FROM=39n TO=56n
.meas tran ecyc1_X_ID_05_100_500_05 INTEG V(X_ID_05_100_500_05.pwpC) FROM=99n TO=123n
.meas tran ecyc2_X_ID_05_100_500_05 INTEG V(X_ID_05_100_500_05.pwpC) FROM=123n TO=139n
.meas tran ecycT_X_ID_05_100_500_05 INTEG V(X_ID_05_100_500_05.pwpC) FROM=99n TO=139n
.meas tran vraA_X_ID_05_100_500_05 MAX V(X_ID_05_100_500_05.rAp) FROM=9n TO=26n
.meas tran vraB_X_ID_05_100_500_05 MIN V(X_ID_05_100_500_05.rBq) FROM=39n TO=56n
.meas tran vlnA_X_ID_05_100_500_05 MAX V(X_ID_05_100_500_05.drvA) FROM=9n TO=26n
.meas tran epush_X_ID_05_100_500_10 INTEG V(X_ID_05_100_500_10.pwpA) FROM=9n TO=26n
.meas tran epull_X_ID_05_100_500_10 INTEG V(X_ID_05_100_500_10.pwpB) FROM=39n TO=56n
.meas tran ecyc1_X_ID_05_100_500_10 INTEG V(X_ID_05_100_500_10.pwpC) FROM=99n TO=123n
.meas tran ecyc2_X_ID_05_100_500_10 INTEG V(X_ID_05_100_500_10.pwpC) FROM=123n TO=139n
.meas tran ecycT_X_ID_05_100_500_10 INTEG V(X_ID_05_100_500_10.pwpC) FROM=99n TO=139n
.meas tran vraA_X_ID_05_100_500_10 MAX V(X_ID_05_100_500_10.rAp) FROM=9n TO=26n
.meas tran vraB_X_ID_05_100_500_10 MIN V(X_ID_05_100_500_10.rBq) FROM=39n TO=56n
.meas tran vlnA_X_ID_05_100_500_10 MAX V(X_ID_05_100_500_10.drvA) FROM=9n TO=26n
.meas tran epush_X_ID_10_05_100_05 INTEG V(X_ID_10_05_100_05.pwpA) FROM=9n TO=26n
.meas tran epull_X_ID_10_05_100_05 INTEG V(X_ID_10_05_100_05.pwpB) FROM=39n TO=56n
.meas tran ecyc1_X_ID_10_05_100_05 INTEG V(X_ID_10_05_100_05.pwpC) FROM=99n TO=123n
.meas tran ecyc2_X_ID_10_05_100_05 INTEG V(X_ID_10_05_100_05.pwpC) FROM=123n TO=139n
.meas tran ecycT_X_ID_10_05_100_05 INTEG V(X_ID_10_05_100_05.pwpC) FROM=99n TO=139n
.meas tran vraA_X_ID_10_05_100_05 MAX V(X_ID_10_05_100_05.rAp) FROM=9n TO=26n
.meas tran vraB_X_ID_10_05_100_05 MIN V(X_ID_10_05_100_05.rBq) FROM=39n TO=56n
.meas tran vlnA_X_ID_10_05_100_05 MAX V(X_ID_10_05_100_05.drvA) FROM=9n TO=26n
.meas tran epush_X_ID_10_05_100_10 INTEG V(X_ID_10_05_100_10.pwpA) FROM=9n TO=26n
.meas tran epull_X_ID_10_05_100_10 INTEG V(X_ID_10_05_100_10.pwpB) FROM=39n TO=56n
.meas tran ecyc1_X_ID_10_05_100_10 INTEG V(X_ID_10_05_100_10.pwpC) FROM=99n TO=123n
.meas tran ecyc2_X_ID_10_05_100_10 INTEG V(X_ID_10_05_100_10.pwpC) FROM=123n TO=139n
.meas tran ecycT_X_ID_10_05_100_10 INTEG V(X_ID_10_05_100_10.pwpC) FROM=99n TO=139n
.meas tran vraA_X_ID_10_05_100_10 MAX V(X_ID_10_05_100_10.rAp) FROM=9n TO=26n
.meas tran vraB_X_ID_10_05_100_10 MIN V(X_ID_10_05_100_10.rBq) FROM=39n TO=56n
.meas tran vlnA_X_ID_10_05_100_10 MAX V(X_ID_10_05_100_10.drvA) FROM=9n TO=26n
.meas tran epush_X_ID_10_05_500_05 INTEG V(X_ID_10_05_500_05.pwpA) FROM=9n TO=26n
.meas tran epull_X_ID_10_05_500_05 INTEG V(X_ID_10_05_500_05.pwpB) FROM=39n TO=56n
.meas tran ecyc1_X_ID_10_05_500_05 INTEG V(X_ID_10_05_500_05.pwpC) FROM=99n TO=123n
.meas tran ecyc2_X_ID_10_05_500_05 INTEG V(X_ID_10_05_500_05.pwpC) FROM=123n TO=139n
.meas tran ecycT_X_ID_10_05_500_05 INTEG V(X_ID_10_05_500_05.pwpC) FROM=99n TO=139n
.meas tran vraA_X_ID_10_05_500_05 MAX V(X_ID_10_05_500_05.rAp) FROM=9n TO=26n
.meas tran vraB_X_ID_10_05_500_05 MIN V(X_ID_10_05_500_05.rBq) FROM=39n TO=56n
.meas tran vlnA_X_ID_10_05_500_05 MAX V(X_ID_10_05_500_05.drvA) FROM=9n TO=26n
.meas tran epush_X_ID_10_05_500_10 INTEG V(X_ID_10_05_500_10.pwpA) FROM=9n TO=26n
.meas tran epull_X_ID_10_05_500_10 INTEG V(X_ID_10_05_500_10.pwpB) FROM=39n TO=56n
.meas tran ecyc1_X_ID_10_05_500_10 INTEG V(X_ID_10_05_500_10.pwpC) FROM=99n TO=123n
.meas tran ecyc2_X_ID_10_05_500_10 INTEG V(X_ID_10_05_500_10.pwpC) FROM=123n TO=139n
.meas tran ecycT_X_ID_10_05_500_10 INTEG V(X_ID_10_05_500_10.pwpC) FROM=99n TO=139n
.meas tran vraA_X_ID_10_05_500_10 MAX V(X_ID_10_05_500_10.rAp) FROM=9n TO=26n
.meas tran vraB_X_ID_10_05_500_10 MIN V(X_ID_10_05_500_10.rBq) FROM=39n TO=56n
.meas tran vlnA_X_ID_10_05_500_10 MAX V(X_ID_10_05_500_10.drvA) FROM=9n TO=26n
.meas tran epush_X_ID_10_10_100_05 INTEG V(X_ID_10_10_100_05.pwpA) FROM=9n TO=26n
.meas tran epull_X_ID_10_10_100_05 INTEG V(X_ID_10_10_100_05.pwpB) FROM=39n TO=56n
.meas tran ecyc1_X_ID_10_10_100_05 INTEG V(X_ID_10_10_100_05.pwpC) FROM=99n TO=123n
.meas tran ecyc2_X_ID_10_10_100_05 INTEG V(X_ID_10_10_100_05.pwpC) FROM=123n TO=139n
.meas tran ecycT_X_ID_10_10_100_05 INTEG V(X_ID_10_10_100_05.pwpC) FROM=99n TO=139n
.meas tran vraA_X_ID_10_10_100_05 MAX V(X_ID_10_10_100_05.rAp) FROM=9n TO=26n
.meas tran vraB_X_ID_10_10_100_05 MIN V(X_ID_10_10_100_05.rBq) FROM=39n TO=56n
.meas tran vlnA_X_ID_10_10_100_05 MAX V(X_ID_10_10_100_05.drvA) FROM=9n TO=26n
.meas tran epush_X_ID_10_10_100_10 INTEG V(X_ID_10_10_100_10.pwpA) FROM=9n TO=26n
.meas tran epull_X_ID_10_10_100_10 INTEG V(X_ID_10_10_100_10.pwpB) FROM=39n TO=56n
.meas tran ecyc1_X_ID_10_10_100_10 INTEG V(X_ID_10_10_100_10.pwpC) FROM=99n TO=123n
.meas tran ecyc2_X_ID_10_10_100_10 INTEG V(X_ID_10_10_100_10.pwpC) FROM=123n TO=139n
.meas tran ecycT_X_ID_10_10_100_10 INTEG V(X_ID_10_10_100_10.pwpC) FROM=99n TO=139n
.meas tran vraA_X_ID_10_10_100_10 MAX V(X_ID_10_10_100_10.rAp) FROM=9n TO=26n
.meas tran vraB_X_ID_10_10_100_10 MIN V(X_ID_10_10_100_10.rBq) FROM=39n TO=56n
.meas tran vlnA_X_ID_10_10_100_10 MAX V(X_ID_10_10_100_10.drvA) FROM=9n TO=26n
.meas tran epush_X_ID_10_10_500_05 INTEG V(X_ID_10_10_500_05.pwpA) FROM=9n TO=26n
.meas tran epull_X_ID_10_10_500_05 INTEG V(X_ID_10_10_500_05.pwpB) FROM=39n TO=56n
.meas tran ecyc1_X_ID_10_10_500_05 INTEG V(X_ID_10_10_500_05.pwpC) FROM=99n TO=123n
.meas tran ecyc2_X_ID_10_10_500_05 INTEG V(X_ID_10_10_500_05.pwpC) FROM=123n TO=139n
.meas tran ecycT_X_ID_10_10_500_05 INTEG V(X_ID_10_10_500_05.pwpC) FROM=99n TO=139n
.meas tran vraA_X_ID_10_10_500_05 MAX V(X_ID_10_10_500_05.rAp) FROM=9n TO=26n
.meas tran vraB_X_ID_10_10_500_05 MIN V(X_ID_10_10_500_05.rBq) FROM=39n TO=56n
.meas tran vlnA_X_ID_10_10_500_05 MAX V(X_ID_10_10_500_05.drvA) FROM=9n TO=26n
.meas tran epush_X_ID_10_10_500_10 INTEG V(X_ID_10_10_500_10.pwpA) FROM=9n TO=26n
.meas tran epull_X_ID_10_10_500_10 INTEG V(X_ID_10_10_500_10.pwpB) FROM=39n TO=56n
.meas tran ecyc1_X_ID_10_10_500_10 INTEG V(X_ID_10_10_500_10.pwpC) FROM=99n TO=123n
.meas tran ecyc2_X_ID_10_10_500_10 INTEG V(X_ID_10_10_500_10.pwpC) FROM=123n TO=139n
.meas tran ecycT_X_ID_10_10_500_10 INTEG V(X_ID_10_10_500_10.pwpC) FROM=99n TO=139n
.meas tran vraA_X_ID_10_10_500_10 MAX V(X_ID_10_10_500_10.rAp) FROM=9n TO=26n
.meas tran vraB_X_ID_10_10_500_10 MIN V(X_ID_10_10_500_10.rBq) FROM=39n TO=56n
.meas tran vlnA_X_ID_10_10_500_10 MAX V(X_ID_10_10_500_10.drvA) FROM=9n TO=26n
.meas tran epush_X_ID_10_30_100_05 INTEG V(X_ID_10_30_100_05.pwpA) FROM=9n TO=26n
.meas tran epull_X_ID_10_30_100_05 INTEG V(X_ID_10_30_100_05.pwpB) FROM=39n TO=56n
.meas tran ecyc1_X_ID_10_30_100_05 INTEG V(X_ID_10_30_100_05.pwpC) FROM=99n TO=123n
.meas tran ecyc2_X_ID_10_30_100_05 INTEG V(X_ID_10_30_100_05.pwpC) FROM=123n TO=139n
.meas tran ecycT_X_ID_10_30_100_05 INTEG V(X_ID_10_30_100_05.pwpC) FROM=99n TO=139n
.meas tran vraA_X_ID_10_30_100_05 MAX V(X_ID_10_30_100_05.rAp) FROM=9n TO=26n
.meas tran vraB_X_ID_10_30_100_05 MIN V(X_ID_10_30_100_05.rBq) FROM=39n TO=56n
.meas tran vlnA_X_ID_10_30_100_05 MAX V(X_ID_10_30_100_05.drvA) FROM=9n TO=26n
.meas tran epush_X_ID_10_30_100_10 INTEG V(X_ID_10_30_100_10.pwpA) FROM=9n TO=26n
.meas tran epull_X_ID_10_30_100_10 INTEG V(X_ID_10_30_100_10.pwpB) FROM=39n TO=56n
.meas tran ecyc1_X_ID_10_30_100_10 INTEG V(X_ID_10_30_100_10.pwpC) FROM=99n TO=123n
.meas tran ecyc2_X_ID_10_30_100_10 INTEG V(X_ID_10_30_100_10.pwpC) FROM=123n TO=139n
.meas tran ecycT_X_ID_10_30_100_10 INTEG V(X_ID_10_30_100_10.pwpC) FROM=99n TO=139n
.meas tran vraA_X_ID_10_30_100_10 MAX V(X_ID_10_30_100_10.rAp) FROM=9n TO=26n
.meas tran vraB_X_ID_10_30_100_10 MIN V(X_ID_10_30_100_10.rBq) FROM=39n TO=56n
.meas tran vlnA_X_ID_10_30_100_10 MAX V(X_ID_10_30_100_10.drvA) FROM=9n TO=26n
.meas tran epush_X_ID_10_30_500_05 INTEG V(X_ID_10_30_500_05.pwpA) FROM=9n TO=26n
.meas tran epull_X_ID_10_30_500_05 INTEG V(X_ID_10_30_500_05.pwpB) FROM=39n TO=56n
.meas tran ecyc1_X_ID_10_30_500_05 INTEG V(X_ID_10_30_500_05.pwpC) FROM=99n TO=123n
.meas tran ecyc2_X_ID_10_30_500_05 INTEG V(X_ID_10_30_500_05.pwpC) FROM=123n TO=139n
.meas tran ecycT_X_ID_10_30_500_05 INTEG V(X_ID_10_30_500_05.pwpC) FROM=99n TO=139n
.meas tran vraA_X_ID_10_30_500_05 MAX V(X_ID_10_30_500_05.rAp) FROM=9n TO=26n
.meas tran vraB_X_ID_10_30_500_05 MIN V(X_ID_10_30_500_05.rBq) FROM=39n TO=56n
.meas tran vlnA_X_ID_10_30_500_05 MAX V(X_ID_10_30_500_05.drvA) FROM=9n TO=26n
.meas tran epush_X_ID_10_30_500_10 INTEG V(X_ID_10_30_500_10.pwpA) FROM=9n TO=26n
.meas tran epull_X_ID_10_30_500_10 INTEG V(X_ID_10_30_500_10.pwpB) FROM=39n TO=56n
.meas tran ecyc1_X_ID_10_30_500_10 INTEG V(X_ID_10_30_500_10.pwpC) FROM=99n TO=123n
.meas tran ecyc2_X_ID_10_30_500_10 INTEG V(X_ID_10_30_500_10.pwpC) FROM=123n TO=139n
.meas tran ecycT_X_ID_10_30_500_10 INTEG V(X_ID_10_30_500_10.pwpC) FROM=99n TO=139n
.meas tran vraA_X_ID_10_30_500_10 MAX V(X_ID_10_30_500_10.rAp) FROM=9n TO=26n
.meas tran vraB_X_ID_10_30_500_10 MIN V(X_ID_10_30_500_10.rBq) FROM=39n TO=56n
.meas tran vlnA_X_ID_10_30_500_10 MAX V(X_ID_10_30_500_10.drvA) FROM=9n TO=26n
.meas tran epush_X_ID_10_100_100_05 INTEG V(X_ID_10_100_100_05.pwpA) FROM=9n TO=26n
.meas tran epull_X_ID_10_100_100_05 INTEG V(X_ID_10_100_100_05.pwpB) FROM=39n TO=56n
.meas tran ecyc1_X_ID_10_100_100_05 INTEG V(X_ID_10_100_100_05.pwpC) FROM=99n TO=123n
.meas tran ecyc2_X_ID_10_100_100_05 INTEG V(X_ID_10_100_100_05.pwpC) FROM=123n TO=139n
.meas tran ecycT_X_ID_10_100_100_05 INTEG V(X_ID_10_100_100_05.pwpC) FROM=99n TO=139n
.meas tran vraA_X_ID_10_100_100_05 MAX V(X_ID_10_100_100_05.rAp) FROM=9n TO=26n
.meas tran vraB_X_ID_10_100_100_05 MIN V(X_ID_10_100_100_05.rBq) FROM=39n TO=56n
.meas tran vlnA_X_ID_10_100_100_05 MAX V(X_ID_10_100_100_05.drvA) FROM=9n TO=26n
.meas tran epush_X_ID_10_100_100_10 INTEG V(X_ID_10_100_100_10.pwpA) FROM=9n TO=26n
.meas tran epull_X_ID_10_100_100_10 INTEG V(X_ID_10_100_100_10.pwpB) FROM=39n TO=56n
.meas tran ecyc1_X_ID_10_100_100_10 INTEG V(X_ID_10_100_100_10.pwpC) FROM=99n TO=123n
.meas tran ecyc2_X_ID_10_100_100_10 INTEG V(X_ID_10_100_100_10.pwpC) FROM=123n TO=139n
.meas tran ecycT_X_ID_10_100_100_10 INTEG V(X_ID_10_100_100_10.pwpC) FROM=99n TO=139n
.meas tran vraA_X_ID_10_100_100_10 MAX V(X_ID_10_100_100_10.rAp) FROM=9n TO=26n
.meas tran vraB_X_ID_10_100_100_10 MIN V(X_ID_10_100_100_10.rBq) FROM=39n TO=56n
.meas tran vlnA_X_ID_10_100_100_10 MAX V(X_ID_10_100_100_10.drvA) FROM=9n TO=26n
.meas tran epush_X_ID_10_100_500_05 INTEG V(X_ID_10_100_500_05.pwpA) FROM=9n TO=26n
.meas tran epull_X_ID_10_100_500_05 INTEG V(X_ID_10_100_500_05.pwpB) FROM=39n TO=56n
.meas tran ecyc1_X_ID_10_100_500_05 INTEG V(X_ID_10_100_500_05.pwpC) FROM=99n TO=123n
.meas tran ecyc2_X_ID_10_100_500_05 INTEG V(X_ID_10_100_500_05.pwpC) FROM=123n TO=139n
.meas tran ecycT_X_ID_10_100_500_05 INTEG V(X_ID_10_100_500_05.pwpC) FROM=99n TO=139n
.meas tran vraA_X_ID_10_100_500_05 MAX V(X_ID_10_100_500_05.rAp) FROM=9n TO=26n
.meas tran vraB_X_ID_10_100_500_05 MIN V(X_ID_10_100_500_05.rBq) FROM=39n TO=56n
.meas tran vlnA_X_ID_10_100_500_05 MAX V(X_ID_10_100_500_05.drvA) FROM=9n TO=26n
.meas tran epush_X_ID_10_100_500_10 INTEG V(X_ID_10_100_500_10.pwpA) FROM=9n TO=26n
.meas tran epull_X_ID_10_100_500_10 INTEG V(X_ID_10_100_500_10.pwpB) FROM=39n TO=56n
.meas tran ecyc1_X_ID_10_100_500_10 INTEG V(X_ID_10_100_500_10.pwpC) FROM=99n TO=123n
.meas tran ecyc2_X_ID_10_100_500_10 INTEG V(X_ID_10_100_500_10.pwpC) FROM=123n TO=139n
.meas tran ecycT_X_ID_10_100_500_10 INTEG V(X_ID_10_100_500_10.pwpC) FROM=99n TO=139n
.meas tran vraA_X_ID_10_100_500_10 MAX V(X_ID_10_100_500_10.rAp) FROM=9n TO=26n
.meas tran vraB_X_ID_10_100_500_10 MIN V(X_ID_10_100_500_10.rBq) FROM=39n TO=56n
.meas tran vlnA_X_ID_10_100_500_10 MAX V(X_ID_10_100_500_10.drvA) FROM=9n TO=26n
.meas tran epush_X_SC_02_05_100_05 INTEG V(X_SC_02_05_100_05.pwpA) FROM=9n TO=26n
.meas tran epull_X_SC_02_05_100_05 INTEG V(X_SC_02_05_100_05.pwpB) FROM=39n TO=56n
.meas tran ecyc1_X_SC_02_05_100_05 INTEG V(X_SC_02_05_100_05.pwpC) FROM=99n TO=123n
.meas tran ecyc2_X_SC_02_05_100_05 INTEG V(X_SC_02_05_100_05.pwpC) FROM=123n TO=139n
.meas tran ecycT_X_SC_02_05_100_05 INTEG V(X_SC_02_05_100_05.pwpC) FROM=99n TO=139n
.meas tran vraA_X_SC_02_05_100_05 MAX V(X_SC_02_05_100_05.rAp) FROM=9n TO=26n
.meas tran vraB_X_SC_02_05_100_05 MIN V(X_SC_02_05_100_05.rBq) FROM=39n TO=56n
.meas tran vlnA_X_SC_02_05_100_05 MAX V(X_SC_02_05_100_05.drvA) FROM=9n TO=26n
.meas tran epush_X_SC_02_05_100_10 INTEG V(X_SC_02_05_100_10.pwpA) FROM=9n TO=26n
.meas tran epull_X_SC_02_05_100_10 INTEG V(X_SC_02_05_100_10.pwpB) FROM=39n TO=56n
.meas tran ecyc1_X_SC_02_05_100_10 INTEG V(X_SC_02_05_100_10.pwpC) FROM=99n TO=123n
.meas tran ecyc2_X_SC_02_05_100_10 INTEG V(X_SC_02_05_100_10.pwpC) FROM=123n TO=139n
.meas tran ecycT_X_SC_02_05_100_10 INTEG V(X_SC_02_05_100_10.pwpC) FROM=99n TO=139n
.meas tran vraA_X_SC_02_05_100_10 MAX V(X_SC_02_05_100_10.rAp) FROM=9n TO=26n
.meas tran vraB_X_SC_02_05_100_10 MIN V(X_SC_02_05_100_10.rBq) FROM=39n TO=56n
.meas tran vlnA_X_SC_02_05_100_10 MAX V(X_SC_02_05_100_10.drvA) FROM=9n TO=26n
.meas tran epush_X_SC_02_05_500_05 INTEG V(X_SC_02_05_500_05.pwpA) FROM=9n TO=26n
.meas tran epull_X_SC_02_05_500_05 INTEG V(X_SC_02_05_500_05.pwpB) FROM=39n TO=56n
.meas tran ecyc1_X_SC_02_05_500_05 INTEG V(X_SC_02_05_500_05.pwpC) FROM=99n TO=123n
.meas tran ecyc2_X_SC_02_05_500_05 INTEG V(X_SC_02_05_500_05.pwpC) FROM=123n TO=139n
.meas tran ecycT_X_SC_02_05_500_05 INTEG V(X_SC_02_05_500_05.pwpC) FROM=99n TO=139n
.meas tran vraA_X_SC_02_05_500_05 MAX V(X_SC_02_05_500_05.rAp) FROM=9n TO=26n
.meas tran vraB_X_SC_02_05_500_05 MIN V(X_SC_02_05_500_05.rBq) FROM=39n TO=56n
.meas tran vlnA_X_SC_02_05_500_05 MAX V(X_SC_02_05_500_05.drvA) FROM=9n TO=26n
.meas tran epush_X_SC_02_05_500_10 INTEG V(X_SC_02_05_500_10.pwpA) FROM=9n TO=26n
.meas tran epull_X_SC_02_05_500_10 INTEG V(X_SC_02_05_500_10.pwpB) FROM=39n TO=56n
.meas tran ecyc1_X_SC_02_05_500_10 INTEG V(X_SC_02_05_500_10.pwpC) FROM=99n TO=123n
.meas tran ecyc2_X_SC_02_05_500_10 INTEG V(X_SC_02_05_500_10.pwpC) FROM=123n TO=139n
.meas tran ecycT_X_SC_02_05_500_10 INTEG V(X_SC_02_05_500_10.pwpC) FROM=99n TO=139n
.meas tran vraA_X_SC_02_05_500_10 MAX V(X_SC_02_05_500_10.rAp) FROM=9n TO=26n
.meas tran vraB_X_SC_02_05_500_10 MIN V(X_SC_02_05_500_10.rBq) FROM=39n TO=56n
.meas tran vlnA_X_SC_02_05_500_10 MAX V(X_SC_02_05_500_10.drvA) FROM=9n TO=26n
.meas tran epush_X_SC_02_10_100_05 INTEG V(X_SC_02_10_100_05.pwpA) FROM=9n TO=26n
.meas tran epull_X_SC_02_10_100_05 INTEG V(X_SC_02_10_100_05.pwpB) FROM=39n TO=56n
.meas tran ecyc1_X_SC_02_10_100_05 INTEG V(X_SC_02_10_100_05.pwpC) FROM=99n TO=123n
.meas tran ecyc2_X_SC_02_10_100_05 INTEG V(X_SC_02_10_100_05.pwpC) FROM=123n TO=139n
.meas tran ecycT_X_SC_02_10_100_05 INTEG V(X_SC_02_10_100_05.pwpC) FROM=99n TO=139n
.meas tran vraA_X_SC_02_10_100_05 MAX V(X_SC_02_10_100_05.rAp) FROM=9n TO=26n
.meas tran vraB_X_SC_02_10_100_05 MIN V(X_SC_02_10_100_05.rBq) FROM=39n TO=56n
.meas tran vlnA_X_SC_02_10_100_05 MAX V(X_SC_02_10_100_05.drvA) FROM=9n TO=26n
.meas tran epush_X_SC_02_10_100_10 INTEG V(X_SC_02_10_100_10.pwpA) FROM=9n TO=26n
.meas tran epull_X_SC_02_10_100_10 INTEG V(X_SC_02_10_100_10.pwpB) FROM=39n TO=56n
.meas tran ecyc1_X_SC_02_10_100_10 INTEG V(X_SC_02_10_100_10.pwpC) FROM=99n TO=123n
.meas tran ecyc2_X_SC_02_10_100_10 INTEG V(X_SC_02_10_100_10.pwpC) FROM=123n TO=139n
.meas tran ecycT_X_SC_02_10_100_10 INTEG V(X_SC_02_10_100_10.pwpC) FROM=99n TO=139n
.meas tran vraA_X_SC_02_10_100_10 MAX V(X_SC_02_10_100_10.rAp) FROM=9n TO=26n
.meas tran vraB_X_SC_02_10_100_10 MIN V(X_SC_02_10_100_10.rBq) FROM=39n TO=56n
.meas tran vlnA_X_SC_02_10_100_10 MAX V(X_SC_02_10_100_10.drvA) FROM=9n TO=26n
.meas tran epush_X_SC_02_10_500_05 INTEG V(X_SC_02_10_500_05.pwpA) FROM=9n TO=26n
.meas tran epull_X_SC_02_10_500_05 INTEG V(X_SC_02_10_500_05.pwpB) FROM=39n TO=56n
.meas tran ecyc1_X_SC_02_10_500_05 INTEG V(X_SC_02_10_500_05.pwpC) FROM=99n TO=123n
.meas tran ecyc2_X_SC_02_10_500_05 INTEG V(X_SC_02_10_500_05.pwpC) FROM=123n TO=139n
.meas tran ecycT_X_SC_02_10_500_05 INTEG V(X_SC_02_10_500_05.pwpC) FROM=99n TO=139n
.meas tran vraA_X_SC_02_10_500_05 MAX V(X_SC_02_10_500_05.rAp) FROM=9n TO=26n
.meas tran vraB_X_SC_02_10_500_05 MIN V(X_SC_02_10_500_05.rBq) FROM=39n TO=56n
.meas tran vlnA_X_SC_02_10_500_05 MAX V(X_SC_02_10_500_05.drvA) FROM=9n TO=26n
.meas tran epush_X_SC_02_10_500_10 INTEG V(X_SC_02_10_500_10.pwpA) FROM=9n TO=26n
.meas tran epull_X_SC_02_10_500_10 INTEG V(X_SC_02_10_500_10.pwpB) FROM=39n TO=56n
.meas tran ecyc1_X_SC_02_10_500_10 INTEG V(X_SC_02_10_500_10.pwpC) FROM=99n TO=123n
.meas tran ecyc2_X_SC_02_10_500_10 INTEG V(X_SC_02_10_500_10.pwpC) FROM=123n TO=139n
.meas tran ecycT_X_SC_02_10_500_10 INTEG V(X_SC_02_10_500_10.pwpC) FROM=99n TO=139n
.meas tran vraA_X_SC_02_10_500_10 MAX V(X_SC_02_10_500_10.rAp) FROM=9n TO=26n
.meas tran vraB_X_SC_02_10_500_10 MIN V(X_SC_02_10_500_10.rBq) FROM=39n TO=56n
.meas tran vlnA_X_SC_02_10_500_10 MAX V(X_SC_02_10_500_10.drvA) FROM=9n TO=26n
.meas tran epush_X_SC_02_30_100_05 INTEG V(X_SC_02_30_100_05.pwpA) FROM=9n TO=26n
.meas tran epull_X_SC_02_30_100_05 INTEG V(X_SC_02_30_100_05.pwpB) FROM=39n TO=56n
.meas tran ecyc1_X_SC_02_30_100_05 INTEG V(X_SC_02_30_100_05.pwpC) FROM=99n TO=123n
.meas tran ecyc2_X_SC_02_30_100_05 INTEG V(X_SC_02_30_100_05.pwpC) FROM=123n TO=139n
.meas tran ecycT_X_SC_02_30_100_05 INTEG V(X_SC_02_30_100_05.pwpC) FROM=99n TO=139n
.meas tran vraA_X_SC_02_30_100_05 MAX V(X_SC_02_30_100_05.rAp) FROM=9n TO=26n
.meas tran vraB_X_SC_02_30_100_05 MIN V(X_SC_02_30_100_05.rBq) FROM=39n TO=56n
.meas tran vlnA_X_SC_02_30_100_05 MAX V(X_SC_02_30_100_05.drvA) FROM=9n TO=26n
.meas tran epush_X_SC_02_30_100_10 INTEG V(X_SC_02_30_100_10.pwpA) FROM=9n TO=26n
.meas tran epull_X_SC_02_30_100_10 INTEG V(X_SC_02_30_100_10.pwpB) FROM=39n TO=56n
.meas tran ecyc1_X_SC_02_30_100_10 INTEG V(X_SC_02_30_100_10.pwpC) FROM=99n TO=123n
.meas tran ecyc2_X_SC_02_30_100_10 INTEG V(X_SC_02_30_100_10.pwpC) FROM=123n TO=139n
.meas tran ecycT_X_SC_02_30_100_10 INTEG V(X_SC_02_30_100_10.pwpC) FROM=99n TO=139n
.meas tran vraA_X_SC_02_30_100_10 MAX V(X_SC_02_30_100_10.rAp) FROM=9n TO=26n
.meas tran vraB_X_SC_02_30_100_10 MIN V(X_SC_02_30_100_10.rBq) FROM=39n TO=56n
.meas tran vlnA_X_SC_02_30_100_10 MAX V(X_SC_02_30_100_10.drvA) FROM=9n TO=26n
.meas tran epush_X_SC_02_30_500_05 INTEG V(X_SC_02_30_500_05.pwpA) FROM=9n TO=26n
.meas tran epull_X_SC_02_30_500_05 INTEG V(X_SC_02_30_500_05.pwpB) FROM=39n TO=56n
.meas tran ecyc1_X_SC_02_30_500_05 INTEG V(X_SC_02_30_500_05.pwpC) FROM=99n TO=123n
.meas tran ecyc2_X_SC_02_30_500_05 INTEG V(X_SC_02_30_500_05.pwpC) FROM=123n TO=139n
.meas tran ecycT_X_SC_02_30_500_05 INTEG V(X_SC_02_30_500_05.pwpC) FROM=99n TO=139n
.meas tran vraA_X_SC_02_30_500_05 MAX V(X_SC_02_30_500_05.rAp) FROM=9n TO=26n
.meas tran vraB_X_SC_02_30_500_05 MIN V(X_SC_02_30_500_05.rBq) FROM=39n TO=56n
.meas tran vlnA_X_SC_02_30_500_05 MAX V(X_SC_02_30_500_05.drvA) FROM=9n TO=26n
.meas tran epush_X_SC_02_30_500_10 INTEG V(X_SC_02_30_500_10.pwpA) FROM=9n TO=26n
.meas tran epull_X_SC_02_30_500_10 INTEG V(X_SC_02_30_500_10.pwpB) FROM=39n TO=56n
.meas tran ecyc1_X_SC_02_30_500_10 INTEG V(X_SC_02_30_500_10.pwpC) FROM=99n TO=123n
.meas tran ecyc2_X_SC_02_30_500_10 INTEG V(X_SC_02_30_500_10.pwpC) FROM=123n TO=139n
.meas tran ecycT_X_SC_02_30_500_10 INTEG V(X_SC_02_30_500_10.pwpC) FROM=99n TO=139n
.meas tran vraA_X_SC_02_30_500_10 MAX V(X_SC_02_30_500_10.rAp) FROM=9n TO=26n
.meas tran vraB_X_SC_02_30_500_10 MIN V(X_SC_02_30_500_10.rBq) FROM=39n TO=56n
.meas tran vlnA_X_SC_02_30_500_10 MAX V(X_SC_02_30_500_10.drvA) FROM=9n TO=26n
.meas tran epush_X_SC_02_100_100_05 INTEG V(X_SC_02_100_100_05.pwpA) FROM=9n TO=26n
.meas tran epull_X_SC_02_100_100_05 INTEG V(X_SC_02_100_100_05.pwpB) FROM=39n TO=56n
.meas tran ecyc1_X_SC_02_100_100_05 INTEG V(X_SC_02_100_100_05.pwpC) FROM=99n TO=123n
.meas tran ecyc2_X_SC_02_100_100_05 INTEG V(X_SC_02_100_100_05.pwpC) FROM=123n TO=139n
.meas tran ecycT_X_SC_02_100_100_05 INTEG V(X_SC_02_100_100_05.pwpC) FROM=99n TO=139n
.meas tran vraA_X_SC_02_100_100_05 MAX V(X_SC_02_100_100_05.rAp) FROM=9n TO=26n
.meas tran vraB_X_SC_02_100_100_05 MIN V(X_SC_02_100_100_05.rBq) FROM=39n TO=56n
.meas tran vlnA_X_SC_02_100_100_05 MAX V(X_SC_02_100_100_05.drvA) FROM=9n TO=26n
.meas tran epush_X_SC_02_100_100_10 INTEG V(X_SC_02_100_100_10.pwpA) FROM=9n TO=26n
.meas tran epull_X_SC_02_100_100_10 INTEG V(X_SC_02_100_100_10.pwpB) FROM=39n TO=56n
.meas tran ecyc1_X_SC_02_100_100_10 INTEG V(X_SC_02_100_100_10.pwpC) FROM=99n TO=123n
.meas tran ecyc2_X_SC_02_100_100_10 INTEG V(X_SC_02_100_100_10.pwpC) FROM=123n TO=139n
.meas tran ecycT_X_SC_02_100_100_10 INTEG V(X_SC_02_100_100_10.pwpC) FROM=99n TO=139n
.meas tran vraA_X_SC_02_100_100_10 MAX V(X_SC_02_100_100_10.rAp) FROM=9n TO=26n
.meas tran vraB_X_SC_02_100_100_10 MIN V(X_SC_02_100_100_10.rBq) FROM=39n TO=56n
.meas tran vlnA_X_SC_02_100_100_10 MAX V(X_SC_02_100_100_10.drvA) FROM=9n TO=26n
.meas tran epush_X_SC_02_100_500_05 INTEG V(X_SC_02_100_500_05.pwpA) FROM=9n TO=26n
.meas tran epull_X_SC_02_100_500_05 INTEG V(X_SC_02_100_500_05.pwpB) FROM=39n TO=56n
.meas tran ecyc1_X_SC_02_100_500_05 INTEG V(X_SC_02_100_500_05.pwpC) FROM=99n TO=123n
.meas tran ecyc2_X_SC_02_100_500_05 INTEG V(X_SC_02_100_500_05.pwpC) FROM=123n TO=139n
.meas tran ecycT_X_SC_02_100_500_05 INTEG V(X_SC_02_100_500_05.pwpC) FROM=99n TO=139n
.meas tran vraA_X_SC_02_100_500_05 MAX V(X_SC_02_100_500_05.rAp) FROM=9n TO=26n
.meas tran vraB_X_SC_02_100_500_05 MIN V(X_SC_02_100_500_05.rBq) FROM=39n TO=56n
.meas tran vlnA_X_SC_02_100_500_05 MAX V(X_SC_02_100_500_05.drvA) FROM=9n TO=26n
.meas tran epush_X_SC_02_100_500_10 INTEG V(X_SC_02_100_500_10.pwpA) FROM=9n TO=26n
.meas tran epull_X_SC_02_100_500_10 INTEG V(X_SC_02_100_500_10.pwpB) FROM=39n TO=56n
.meas tran ecyc1_X_SC_02_100_500_10 INTEG V(X_SC_02_100_500_10.pwpC) FROM=99n TO=123n
.meas tran ecyc2_X_SC_02_100_500_10 INTEG V(X_SC_02_100_500_10.pwpC) FROM=123n TO=139n
.meas tran ecycT_X_SC_02_100_500_10 INTEG V(X_SC_02_100_500_10.pwpC) FROM=99n TO=139n
.meas tran vraA_X_SC_02_100_500_10 MAX V(X_SC_02_100_500_10.rAp) FROM=9n TO=26n
.meas tran vraB_X_SC_02_100_500_10 MIN V(X_SC_02_100_500_10.rBq) FROM=39n TO=56n
.meas tran vlnA_X_SC_02_100_500_10 MAX V(X_SC_02_100_500_10.drvA) FROM=9n TO=26n
.meas tran epush_X_SC_05_05_100_05 INTEG V(X_SC_05_05_100_05.pwpA) FROM=9n TO=26n
.meas tran epull_X_SC_05_05_100_05 INTEG V(X_SC_05_05_100_05.pwpB) FROM=39n TO=56n
.meas tran ecyc1_X_SC_05_05_100_05 INTEG V(X_SC_05_05_100_05.pwpC) FROM=99n TO=123n
.meas tran ecyc2_X_SC_05_05_100_05 INTEG V(X_SC_05_05_100_05.pwpC) FROM=123n TO=139n
.meas tran ecycT_X_SC_05_05_100_05 INTEG V(X_SC_05_05_100_05.pwpC) FROM=99n TO=139n
.meas tran vraA_X_SC_05_05_100_05 MAX V(X_SC_05_05_100_05.rAp) FROM=9n TO=26n
.meas tran vraB_X_SC_05_05_100_05 MIN V(X_SC_05_05_100_05.rBq) FROM=39n TO=56n
.meas tran vlnA_X_SC_05_05_100_05 MAX V(X_SC_05_05_100_05.drvA) FROM=9n TO=26n
.meas tran epush_X_SC_05_05_100_10 INTEG V(X_SC_05_05_100_10.pwpA) FROM=9n TO=26n
.meas tran epull_X_SC_05_05_100_10 INTEG V(X_SC_05_05_100_10.pwpB) FROM=39n TO=56n
.meas tran ecyc1_X_SC_05_05_100_10 INTEG V(X_SC_05_05_100_10.pwpC) FROM=99n TO=123n
.meas tran ecyc2_X_SC_05_05_100_10 INTEG V(X_SC_05_05_100_10.pwpC) FROM=123n TO=139n
.meas tran ecycT_X_SC_05_05_100_10 INTEG V(X_SC_05_05_100_10.pwpC) FROM=99n TO=139n
.meas tran vraA_X_SC_05_05_100_10 MAX V(X_SC_05_05_100_10.rAp) FROM=9n TO=26n
.meas tran vraB_X_SC_05_05_100_10 MIN V(X_SC_05_05_100_10.rBq) FROM=39n TO=56n
.meas tran vlnA_X_SC_05_05_100_10 MAX V(X_SC_05_05_100_10.drvA) FROM=9n TO=26n
.meas tran epush_X_SC_05_05_500_05 INTEG V(X_SC_05_05_500_05.pwpA) FROM=9n TO=26n
.meas tran epull_X_SC_05_05_500_05 INTEG V(X_SC_05_05_500_05.pwpB) FROM=39n TO=56n
.meas tran ecyc1_X_SC_05_05_500_05 INTEG V(X_SC_05_05_500_05.pwpC) FROM=99n TO=123n
.meas tran ecyc2_X_SC_05_05_500_05 INTEG V(X_SC_05_05_500_05.pwpC) FROM=123n TO=139n
.meas tran ecycT_X_SC_05_05_500_05 INTEG V(X_SC_05_05_500_05.pwpC) FROM=99n TO=139n
.meas tran vraA_X_SC_05_05_500_05 MAX V(X_SC_05_05_500_05.rAp) FROM=9n TO=26n
.meas tran vraB_X_SC_05_05_500_05 MIN V(X_SC_05_05_500_05.rBq) FROM=39n TO=56n
.meas tran vlnA_X_SC_05_05_500_05 MAX V(X_SC_05_05_500_05.drvA) FROM=9n TO=26n
.meas tran epush_X_SC_05_05_500_10 INTEG V(X_SC_05_05_500_10.pwpA) FROM=9n TO=26n
.meas tran epull_X_SC_05_05_500_10 INTEG V(X_SC_05_05_500_10.pwpB) FROM=39n TO=56n
.meas tran ecyc1_X_SC_05_05_500_10 INTEG V(X_SC_05_05_500_10.pwpC) FROM=99n TO=123n
.meas tran ecyc2_X_SC_05_05_500_10 INTEG V(X_SC_05_05_500_10.pwpC) FROM=123n TO=139n
.meas tran ecycT_X_SC_05_05_500_10 INTEG V(X_SC_05_05_500_10.pwpC) FROM=99n TO=139n
.meas tran vraA_X_SC_05_05_500_10 MAX V(X_SC_05_05_500_10.rAp) FROM=9n TO=26n
.meas tran vraB_X_SC_05_05_500_10 MIN V(X_SC_05_05_500_10.rBq) FROM=39n TO=56n
.meas tran vlnA_X_SC_05_05_500_10 MAX V(X_SC_05_05_500_10.drvA) FROM=9n TO=26n
.meas tran epush_X_SC_05_10_100_05 INTEG V(X_SC_05_10_100_05.pwpA) FROM=9n TO=26n
.meas tran epull_X_SC_05_10_100_05 INTEG V(X_SC_05_10_100_05.pwpB) FROM=39n TO=56n
.meas tran ecyc1_X_SC_05_10_100_05 INTEG V(X_SC_05_10_100_05.pwpC) FROM=99n TO=123n
.meas tran ecyc2_X_SC_05_10_100_05 INTEG V(X_SC_05_10_100_05.pwpC) FROM=123n TO=139n
.meas tran ecycT_X_SC_05_10_100_05 INTEG V(X_SC_05_10_100_05.pwpC) FROM=99n TO=139n
.meas tran vraA_X_SC_05_10_100_05 MAX V(X_SC_05_10_100_05.rAp) FROM=9n TO=26n
.meas tran vraB_X_SC_05_10_100_05 MIN V(X_SC_05_10_100_05.rBq) FROM=39n TO=56n
.meas tran vlnA_X_SC_05_10_100_05 MAX V(X_SC_05_10_100_05.drvA) FROM=9n TO=26n
.meas tran epush_X_SC_05_10_100_10 INTEG V(X_SC_05_10_100_10.pwpA) FROM=9n TO=26n
.meas tran epull_X_SC_05_10_100_10 INTEG V(X_SC_05_10_100_10.pwpB) FROM=39n TO=56n
.meas tran ecyc1_X_SC_05_10_100_10 INTEG V(X_SC_05_10_100_10.pwpC) FROM=99n TO=123n
.meas tran ecyc2_X_SC_05_10_100_10 INTEG V(X_SC_05_10_100_10.pwpC) FROM=123n TO=139n
.meas tran ecycT_X_SC_05_10_100_10 INTEG V(X_SC_05_10_100_10.pwpC) FROM=99n TO=139n
.meas tran vraA_X_SC_05_10_100_10 MAX V(X_SC_05_10_100_10.rAp) FROM=9n TO=26n
.meas tran vraB_X_SC_05_10_100_10 MIN V(X_SC_05_10_100_10.rBq) FROM=39n TO=56n
.meas tran vlnA_X_SC_05_10_100_10 MAX V(X_SC_05_10_100_10.drvA) FROM=9n TO=26n
.meas tran epush_X_SC_05_10_500_05 INTEG V(X_SC_05_10_500_05.pwpA) FROM=9n TO=26n
.meas tran epull_X_SC_05_10_500_05 INTEG V(X_SC_05_10_500_05.pwpB) FROM=39n TO=56n
.meas tran ecyc1_X_SC_05_10_500_05 INTEG V(X_SC_05_10_500_05.pwpC) FROM=99n TO=123n
.meas tran ecyc2_X_SC_05_10_500_05 INTEG V(X_SC_05_10_500_05.pwpC) FROM=123n TO=139n
.meas tran ecycT_X_SC_05_10_500_05 INTEG V(X_SC_05_10_500_05.pwpC) FROM=99n TO=139n
.meas tran vraA_X_SC_05_10_500_05 MAX V(X_SC_05_10_500_05.rAp) FROM=9n TO=26n
.meas tran vraB_X_SC_05_10_500_05 MIN V(X_SC_05_10_500_05.rBq) FROM=39n TO=56n
.meas tran vlnA_X_SC_05_10_500_05 MAX V(X_SC_05_10_500_05.drvA) FROM=9n TO=26n
.meas tran epush_X_SC_05_10_500_10 INTEG V(X_SC_05_10_500_10.pwpA) FROM=9n TO=26n
.meas tran epull_X_SC_05_10_500_10 INTEG V(X_SC_05_10_500_10.pwpB) FROM=39n TO=56n
.meas tran ecyc1_X_SC_05_10_500_10 INTEG V(X_SC_05_10_500_10.pwpC) FROM=99n TO=123n
.meas tran ecyc2_X_SC_05_10_500_10 INTEG V(X_SC_05_10_500_10.pwpC) FROM=123n TO=139n
.meas tran ecycT_X_SC_05_10_500_10 INTEG V(X_SC_05_10_500_10.pwpC) FROM=99n TO=139n
.meas tran vraA_X_SC_05_10_500_10 MAX V(X_SC_05_10_500_10.rAp) FROM=9n TO=26n
.meas tran vraB_X_SC_05_10_500_10 MIN V(X_SC_05_10_500_10.rBq) FROM=39n TO=56n
.meas tran vlnA_X_SC_05_10_500_10 MAX V(X_SC_05_10_500_10.drvA) FROM=9n TO=26n
.meas tran epush_X_SC_05_30_100_05 INTEG V(X_SC_05_30_100_05.pwpA) FROM=9n TO=26n
.meas tran epull_X_SC_05_30_100_05 INTEG V(X_SC_05_30_100_05.pwpB) FROM=39n TO=56n
.meas tran ecyc1_X_SC_05_30_100_05 INTEG V(X_SC_05_30_100_05.pwpC) FROM=99n TO=123n
.meas tran ecyc2_X_SC_05_30_100_05 INTEG V(X_SC_05_30_100_05.pwpC) FROM=123n TO=139n
.meas tran ecycT_X_SC_05_30_100_05 INTEG V(X_SC_05_30_100_05.pwpC) FROM=99n TO=139n
.meas tran vraA_X_SC_05_30_100_05 MAX V(X_SC_05_30_100_05.rAp) FROM=9n TO=26n
.meas tran vraB_X_SC_05_30_100_05 MIN V(X_SC_05_30_100_05.rBq) FROM=39n TO=56n
.meas tran vlnA_X_SC_05_30_100_05 MAX V(X_SC_05_30_100_05.drvA) FROM=9n TO=26n
.meas tran epush_X_SC_05_30_100_10 INTEG V(X_SC_05_30_100_10.pwpA) FROM=9n TO=26n
.meas tran epull_X_SC_05_30_100_10 INTEG V(X_SC_05_30_100_10.pwpB) FROM=39n TO=56n
.meas tran ecyc1_X_SC_05_30_100_10 INTEG V(X_SC_05_30_100_10.pwpC) FROM=99n TO=123n
.meas tran ecyc2_X_SC_05_30_100_10 INTEG V(X_SC_05_30_100_10.pwpC) FROM=123n TO=139n
.meas tran ecycT_X_SC_05_30_100_10 INTEG V(X_SC_05_30_100_10.pwpC) FROM=99n TO=139n
.meas tran vraA_X_SC_05_30_100_10 MAX V(X_SC_05_30_100_10.rAp) FROM=9n TO=26n
.meas tran vraB_X_SC_05_30_100_10 MIN V(X_SC_05_30_100_10.rBq) FROM=39n TO=56n
.meas tran vlnA_X_SC_05_30_100_10 MAX V(X_SC_05_30_100_10.drvA) FROM=9n TO=26n
.meas tran epush_X_SC_05_30_500_05 INTEG V(X_SC_05_30_500_05.pwpA) FROM=9n TO=26n
.meas tran epull_X_SC_05_30_500_05 INTEG V(X_SC_05_30_500_05.pwpB) FROM=39n TO=56n
.meas tran ecyc1_X_SC_05_30_500_05 INTEG V(X_SC_05_30_500_05.pwpC) FROM=99n TO=123n
.meas tran ecyc2_X_SC_05_30_500_05 INTEG V(X_SC_05_30_500_05.pwpC) FROM=123n TO=139n
.meas tran ecycT_X_SC_05_30_500_05 INTEG V(X_SC_05_30_500_05.pwpC) FROM=99n TO=139n
.meas tran vraA_X_SC_05_30_500_05 MAX V(X_SC_05_30_500_05.rAp) FROM=9n TO=26n
.meas tran vraB_X_SC_05_30_500_05 MIN V(X_SC_05_30_500_05.rBq) FROM=39n TO=56n
.meas tran vlnA_X_SC_05_30_500_05 MAX V(X_SC_05_30_500_05.drvA) FROM=9n TO=26n
.meas tran epush_X_SC_05_30_500_10 INTEG V(X_SC_05_30_500_10.pwpA) FROM=9n TO=26n
.meas tran epull_X_SC_05_30_500_10 INTEG V(X_SC_05_30_500_10.pwpB) FROM=39n TO=56n
.meas tran ecyc1_X_SC_05_30_500_10 INTEG V(X_SC_05_30_500_10.pwpC) FROM=99n TO=123n
.meas tran ecyc2_X_SC_05_30_500_10 INTEG V(X_SC_05_30_500_10.pwpC) FROM=123n TO=139n
.meas tran ecycT_X_SC_05_30_500_10 INTEG V(X_SC_05_30_500_10.pwpC) FROM=99n TO=139n
.meas tran vraA_X_SC_05_30_500_10 MAX V(X_SC_05_30_500_10.rAp) FROM=9n TO=26n
.meas tran vraB_X_SC_05_30_500_10 MIN V(X_SC_05_30_500_10.rBq) FROM=39n TO=56n
.meas tran vlnA_X_SC_05_30_500_10 MAX V(X_SC_05_30_500_10.drvA) FROM=9n TO=26n
.meas tran epush_X_SC_05_100_100_05 INTEG V(X_SC_05_100_100_05.pwpA) FROM=9n TO=26n
.meas tran epull_X_SC_05_100_100_05 INTEG V(X_SC_05_100_100_05.pwpB) FROM=39n TO=56n
.meas tran ecyc1_X_SC_05_100_100_05 INTEG V(X_SC_05_100_100_05.pwpC) FROM=99n TO=123n
.meas tran ecyc2_X_SC_05_100_100_05 INTEG V(X_SC_05_100_100_05.pwpC) FROM=123n TO=139n
.meas tran ecycT_X_SC_05_100_100_05 INTEG V(X_SC_05_100_100_05.pwpC) FROM=99n TO=139n
.meas tran vraA_X_SC_05_100_100_05 MAX V(X_SC_05_100_100_05.rAp) FROM=9n TO=26n
.meas tran vraB_X_SC_05_100_100_05 MIN V(X_SC_05_100_100_05.rBq) FROM=39n TO=56n
.meas tran vlnA_X_SC_05_100_100_05 MAX V(X_SC_05_100_100_05.drvA) FROM=9n TO=26n
.meas tran epush_X_SC_05_100_100_10 INTEG V(X_SC_05_100_100_10.pwpA) FROM=9n TO=26n
.meas tran epull_X_SC_05_100_100_10 INTEG V(X_SC_05_100_100_10.pwpB) FROM=39n TO=56n
.meas tran ecyc1_X_SC_05_100_100_10 INTEG V(X_SC_05_100_100_10.pwpC) FROM=99n TO=123n
.meas tran ecyc2_X_SC_05_100_100_10 INTEG V(X_SC_05_100_100_10.pwpC) FROM=123n TO=139n
.meas tran ecycT_X_SC_05_100_100_10 INTEG V(X_SC_05_100_100_10.pwpC) FROM=99n TO=139n
.meas tran vraA_X_SC_05_100_100_10 MAX V(X_SC_05_100_100_10.rAp) FROM=9n TO=26n
.meas tran vraB_X_SC_05_100_100_10 MIN V(X_SC_05_100_100_10.rBq) FROM=39n TO=56n
.meas tran vlnA_X_SC_05_100_100_10 MAX V(X_SC_05_100_100_10.drvA) FROM=9n TO=26n
.meas tran epush_X_SC_05_100_500_05 INTEG V(X_SC_05_100_500_05.pwpA) FROM=9n TO=26n
.meas tran epull_X_SC_05_100_500_05 INTEG V(X_SC_05_100_500_05.pwpB) FROM=39n TO=56n
.meas tran ecyc1_X_SC_05_100_500_05 INTEG V(X_SC_05_100_500_05.pwpC) FROM=99n TO=123n
.meas tran ecyc2_X_SC_05_100_500_05 INTEG V(X_SC_05_100_500_05.pwpC) FROM=123n TO=139n
.meas tran ecycT_X_SC_05_100_500_05 INTEG V(X_SC_05_100_500_05.pwpC) FROM=99n TO=139n
.meas tran vraA_X_SC_05_100_500_05 MAX V(X_SC_05_100_500_05.rAp) FROM=9n TO=26n
.meas tran vraB_X_SC_05_100_500_05 MIN V(X_SC_05_100_500_05.rBq) FROM=39n TO=56n
.meas tran vlnA_X_SC_05_100_500_05 MAX V(X_SC_05_100_500_05.drvA) FROM=9n TO=26n
.meas tran epush_X_SC_05_100_500_10 INTEG V(X_SC_05_100_500_10.pwpA) FROM=9n TO=26n
.meas tran epull_X_SC_05_100_500_10 INTEG V(X_SC_05_100_500_10.pwpB) FROM=39n TO=56n
.meas tran ecyc1_X_SC_05_100_500_10 INTEG V(X_SC_05_100_500_10.pwpC) FROM=99n TO=123n
.meas tran ecyc2_X_SC_05_100_500_10 INTEG V(X_SC_05_100_500_10.pwpC) FROM=123n TO=139n
.meas tran ecycT_X_SC_05_100_500_10 INTEG V(X_SC_05_100_500_10.pwpC) FROM=99n TO=139n
.meas tran vraA_X_SC_05_100_500_10 MAX V(X_SC_05_100_500_10.rAp) FROM=9n TO=26n
.meas tran vraB_X_SC_05_100_500_10 MIN V(X_SC_05_100_500_10.rBq) FROM=39n TO=56n
.meas tran vlnA_X_SC_05_100_500_10 MAX V(X_SC_05_100_500_10.drvA) FROM=9n TO=26n
.meas tran epush_X_SC_10_05_100_05 INTEG V(X_SC_10_05_100_05.pwpA) FROM=9n TO=26n
.meas tran epull_X_SC_10_05_100_05 INTEG V(X_SC_10_05_100_05.pwpB) FROM=39n TO=56n
.meas tran ecyc1_X_SC_10_05_100_05 INTEG V(X_SC_10_05_100_05.pwpC) FROM=99n TO=123n
.meas tran ecyc2_X_SC_10_05_100_05 INTEG V(X_SC_10_05_100_05.pwpC) FROM=123n TO=139n
.meas tran ecycT_X_SC_10_05_100_05 INTEG V(X_SC_10_05_100_05.pwpC) FROM=99n TO=139n
.meas tran vraA_X_SC_10_05_100_05 MAX V(X_SC_10_05_100_05.rAp) FROM=9n TO=26n
.meas tran vraB_X_SC_10_05_100_05 MIN V(X_SC_10_05_100_05.rBq) FROM=39n TO=56n
.meas tran vlnA_X_SC_10_05_100_05 MAX V(X_SC_10_05_100_05.drvA) FROM=9n TO=26n
.meas tran epush_X_SC_10_05_100_10 INTEG V(X_SC_10_05_100_10.pwpA) FROM=9n TO=26n
.meas tran epull_X_SC_10_05_100_10 INTEG V(X_SC_10_05_100_10.pwpB) FROM=39n TO=56n
.meas tran ecyc1_X_SC_10_05_100_10 INTEG V(X_SC_10_05_100_10.pwpC) FROM=99n TO=123n
.meas tran ecyc2_X_SC_10_05_100_10 INTEG V(X_SC_10_05_100_10.pwpC) FROM=123n TO=139n
.meas tran ecycT_X_SC_10_05_100_10 INTEG V(X_SC_10_05_100_10.pwpC) FROM=99n TO=139n
.meas tran vraA_X_SC_10_05_100_10 MAX V(X_SC_10_05_100_10.rAp) FROM=9n TO=26n
.meas tran vraB_X_SC_10_05_100_10 MIN V(X_SC_10_05_100_10.rBq) FROM=39n TO=56n
.meas tran vlnA_X_SC_10_05_100_10 MAX V(X_SC_10_05_100_10.drvA) FROM=9n TO=26n
.meas tran epush_X_SC_10_05_500_05 INTEG V(X_SC_10_05_500_05.pwpA) FROM=9n TO=26n
.meas tran epull_X_SC_10_05_500_05 INTEG V(X_SC_10_05_500_05.pwpB) FROM=39n TO=56n
.meas tran ecyc1_X_SC_10_05_500_05 INTEG V(X_SC_10_05_500_05.pwpC) FROM=99n TO=123n
.meas tran ecyc2_X_SC_10_05_500_05 INTEG V(X_SC_10_05_500_05.pwpC) FROM=123n TO=139n
.meas tran ecycT_X_SC_10_05_500_05 INTEG V(X_SC_10_05_500_05.pwpC) FROM=99n TO=139n
.meas tran vraA_X_SC_10_05_500_05 MAX V(X_SC_10_05_500_05.rAp) FROM=9n TO=26n
.meas tran vraB_X_SC_10_05_500_05 MIN V(X_SC_10_05_500_05.rBq) FROM=39n TO=56n
.meas tran vlnA_X_SC_10_05_500_05 MAX V(X_SC_10_05_500_05.drvA) FROM=9n TO=26n
.meas tran epush_X_SC_10_05_500_10 INTEG V(X_SC_10_05_500_10.pwpA) FROM=9n TO=26n
.meas tran epull_X_SC_10_05_500_10 INTEG V(X_SC_10_05_500_10.pwpB) FROM=39n TO=56n
.meas tran ecyc1_X_SC_10_05_500_10 INTEG V(X_SC_10_05_500_10.pwpC) FROM=99n TO=123n
.meas tran ecyc2_X_SC_10_05_500_10 INTEG V(X_SC_10_05_500_10.pwpC) FROM=123n TO=139n
.meas tran ecycT_X_SC_10_05_500_10 INTEG V(X_SC_10_05_500_10.pwpC) FROM=99n TO=139n
.meas tran vraA_X_SC_10_05_500_10 MAX V(X_SC_10_05_500_10.rAp) FROM=9n TO=26n
.meas tran vraB_X_SC_10_05_500_10 MIN V(X_SC_10_05_500_10.rBq) FROM=39n TO=56n
.meas tran vlnA_X_SC_10_05_500_10 MAX V(X_SC_10_05_500_10.drvA) FROM=9n TO=26n
.meas tran epush_X_SC_10_10_100_05 INTEG V(X_SC_10_10_100_05.pwpA) FROM=9n TO=26n
.meas tran epull_X_SC_10_10_100_05 INTEG V(X_SC_10_10_100_05.pwpB) FROM=39n TO=56n
.meas tran ecyc1_X_SC_10_10_100_05 INTEG V(X_SC_10_10_100_05.pwpC) FROM=99n TO=123n
.meas tran ecyc2_X_SC_10_10_100_05 INTEG V(X_SC_10_10_100_05.pwpC) FROM=123n TO=139n
.meas tran ecycT_X_SC_10_10_100_05 INTEG V(X_SC_10_10_100_05.pwpC) FROM=99n TO=139n
.meas tran vraA_X_SC_10_10_100_05 MAX V(X_SC_10_10_100_05.rAp) FROM=9n TO=26n
.meas tran vraB_X_SC_10_10_100_05 MIN V(X_SC_10_10_100_05.rBq) FROM=39n TO=56n
.meas tran vlnA_X_SC_10_10_100_05 MAX V(X_SC_10_10_100_05.drvA) FROM=9n TO=26n
.meas tran epush_X_SC_10_10_100_10 INTEG V(X_SC_10_10_100_10.pwpA) FROM=9n TO=26n
.meas tran epull_X_SC_10_10_100_10 INTEG V(X_SC_10_10_100_10.pwpB) FROM=39n TO=56n
.meas tran ecyc1_X_SC_10_10_100_10 INTEG V(X_SC_10_10_100_10.pwpC) FROM=99n TO=123n
.meas tran ecyc2_X_SC_10_10_100_10 INTEG V(X_SC_10_10_100_10.pwpC) FROM=123n TO=139n
.meas tran ecycT_X_SC_10_10_100_10 INTEG V(X_SC_10_10_100_10.pwpC) FROM=99n TO=139n
.meas tran vraA_X_SC_10_10_100_10 MAX V(X_SC_10_10_100_10.rAp) FROM=9n TO=26n
.meas tran vraB_X_SC_10_10_100_10 MIN V(X_SC_10_10_100_10.rBq) FROM=39n TO=56n
.meas tran vlnA_X_SC_10_10_100_10 MAX V(X_SC_10_10_100_10.drvA) FROM=9n TO=26n
.meas tran epush_X_SC_10_10_500_05 INTEG V(X_SC_10_10_500_05.pwpA) FROM=9n TO=26n
.meas tran epull_X_SC_10_10_500_05 INTEG V(X_SC_10_10_500_05.pwpB) FROM=39n TO=56n
.meas tran ecyc1_X_SC_10_10_500_05 INTEG V(X_SC_10_10_500_05.pwpC) FROM=99n TO=123n
.meas tran ecyc2_X_SC_10_10_500_05 INTEG V(X_SC_10_10_500_05.pwpC) FROM=123n TO=139n
.meas tran ecycT_X_SC_10_10_500_05 INTEG V(X_SC_10_10_500_05.pwpC) FROM=99n TO=139n
.meas tran vraA_X_SC_10_10_500_05 MAX V(X_SC_10_10_500_05.rAp) FROM=9n TO=26n
.meas tran vraB_X_SC_10_10_500_05 MIN V(X_SC_10_10_500_05.rBq) FROM=39n TO=56n
.meas tran vlnA_X_SC_10_10_500_05 MAX V(X_SC_10_10_500_05.drvA) FROM=9n TO=26n
.meas tran epush_X_SC_10_10_500_10 INTEG V(X_SC_10_10_500_10.pwpA) FROM=9n TO=26n
.meas tran epull_X_SC_10_10_500_10 INTEG V(X_SC_10_10_500_10.pwpB) FROM=39n TO=56n
.meas tran ecyc1_X_SC_10_10_500_10 INTEG V(X_SC_10_10_500_10.pwpC) FROM=99n TO=123n
.meas tran ecyc2_X_SC_10_10_500_10 INTEG V(X_SC_10_10_500_10.pwpC) FROM=123n TO=139n
.meas tran ecycT_X_SC_10_10_500_10 INTEG V(X_SC_10_10_500_10.pwpC) FROM=99n TO=139n
.meas tran vraA_X_SC_10_10_500_10 MAX V(X_SC_10_10_500_10.rAp) FROM=9n TO=26n
.meas tran vraB_X_SC_10_10_500_10 MIN V(X_SC_10_10_500_10.rBq) FROM=39n TO=56n
.meas tran vlnA_X_SC_10_10_500_10 MAX V(X_SC_10_10_500_10.drvA) FROM=9n TO=26n
.meas tran epush_X_SC_10_30_100_05 INTEG V(X_SC_10_30_100_05.pwpA) FROM=9n TO=26n
.meas tran epull_X_SC_10_30_100_05 INTEG V(X_SC_10_30_100_05.pwpB) FROM=39n TO=56n
.meas tran ecyc1_X_SC_10_30_100_05 INTEG V(X_SC_10_30_100_05.pwpC) FROM=99n TO=123n
.meas tran ecyc2_X_SC_10_30_100_05 INTEG V(X_SC_10_30_100_05.pwpC) FROM=123n TO=139n
.meas tran ecycT_X_SC_10_30_100_05 INTEG V(X_SC_10_30_100_05.pwpC) FROM=99n TO=139n
.meas tran vraA_X_SC_10_30_100_05 MAX V(X_SC_10_30_100_05.rAp) FROM=9n TO=26n
.meas tran vraB_X_SC_10_30_100_05 MIN V(X_SC_10_30_100_05.rBq) FROM=39n TO=56n
.meas tran vlnA_X_SC_10_30_100_05 MAX V(X_SC_10_30_100_05.drvA) FROM=9n TO=26n
.meas tran epush_X_SC_10_30_100_10 INTEG V(X_SC_10_30_100_10.pwpA) FROM=9n TO=26n
.meas tran epull_X_SC_10_30_100_10 INTEG V(X_SC_10_30_100_10.pwpB) FROM=39n TO=56n
.meas tran ecyc1_X_SC_10_30_100_10 INTEG V(X_SC_10_30_100_10.pwpC) FROM=99n TO=123n
.meas tran ecyc2_X_SC_10_30_100_10 INTEG V(X_SC_10_30_100_10.pwpC) FROM=123n TO=139n
.meas tran ecycT_X_SC_10_30_100_10 INTEG V(X_SC_10_30_100_10.pwpC) FROM=99n TO=139n
.meas tran vraA_X_SC_10_30_100_10 MAX V(X_SC_10_30_100_10.rAp) FROM=9n TO=26n
.meas tran vraB_X_SC_10_30_100_10 MIN V(X_SC_10_30_100_10.rBq) FROM=39n TO=56n
.meas tran vlnA_X_SC_10_30_100_10 MAX V(X_SC_10_30_100_10.drvA) FROM=9n TO=26n
.meas tran epush_X_SC_10_30_500_05 INTEG V(X_SC_10_30_500_05.pwpA) FROM=9n TO=26n
.meas tran epull_X_SC_10_30_500_05 INTEG V(X_SC_10_30_500_05.pwpB) FROM=39n TO=56n
.meas tran ecyc1_X_SC_10_30_500_05 INTEG V(X_SC_10_30_500_05.pwpC) FROM=99n TO=123n
.meas tran ecyc2_X_SC_10_30_500_05 INTEG V(X_SC_10_30_500_05.pwpC) FROM=123n TO=139n
.meas tran ecycT_X_SC_10_30_500_05 INTEG V(X_SC_10_30_500_05.pwpC) FROM=99n TO=139n
.meas tran vraA_X_SC_10_30_500_05 MAX V(X_SC_10_30_500_05.rAp) FROM=9n TO=26n
.meas tran vraB_X_SC_10_30_500_05 MIN V(X_SC_10_30_500_05.rBq) FROM=39n TO=56n
.meas tran vlnA_X_SC_10_30_500_05 MAX V(X_SC_10_30_500_05.drvA) FROM=9n TO=26n
.meas tran epush_X_SC_10_30_500_10 INTEG V(X_SC_10_30_500_10.pwpA) FROM=9n TO=26n
.meas tran epull_X_SC_10_30_500_10 INTEG V(X_SC_10_30_500_10.pwpB) FROM=39n TO=56n
.meas tran ecyc1_X_SC_10_30_500_10 INTEG V(X_SC_10_30_500_10.pwpC) FROM=99n TO=123n
.meas tran ecyc2_X_SC_10_30_500_10 INTEG V(X_SC_10_30_500_10.pwpC) FROM=123n TO=139n
.meas tran ecycT_X_SC_10_30_500_10 INTEG V(X_SC_10_30_500_10.pwpC) FROM=99n TO=139n
.meas tran vraA_X_SC_10_30_500_10 MAX V(X_SC_10_30_500_10.rAp) FROM=9n TO=26n
.meas tran vraB_X_SC_10_30_500_10 MIN V(X_SC_10_30_500_10.rBq) FROM=39n TO=56n
.meas tran vlnA_X_SC_10_30_500_10 MAX V(X_SC_10_30_500_10.drvA) FROM=9n TO=26n
.meas tran epush_X_SC_10_100_100_05 INTEG V(X_SC_10_100_100_05.pwpA) FROM=9n TO=26n
.meas tran epull_X_SC_10_100_100_05 INTEG V(X_SC_10_100_100_05.pwpB) FROM=39n TO=56n
.meas tran ecyc1_X_SC_10_100_100_05 INTEG V(X_SC_10_100_100_05.pwpC) FROM=99n TO=123n
.meas tran ecyc2_X_SC_10_100_100_05 INTEG V(X_SC_10_100_100_05.pwpC) FROM=123n TO=139n
.meas tran ecycT_X_SC_10_100_100_05 INTEG V(X_SC_10_100_100_05.pwpC) FROM=99n TO=139n
.meas tran vraA_X_SC_10_100_100_05 MAX V(X_SC_10_100_100_05.rAp) FROM=9n TO=26n
.meas tran vraB_X_SC_10_100_100_05 MIN V(X_SC_10_100_100_05.rBq) FROM=39n TO=56n
.meas tran vlnA_X_SC_10_100_100_05 MAX V(X_SC_10_100_100_05.drvA) FROM=9n TO=26n
.meas tran epush_X_SC_10_100_100_10 INTEG V(X_SC_10_100_100_10.pwpA) FROM=9n TO=26n
.meas tran epull_X_SC_10_100_100_10 INTEG V(X_SC_10_100_100_10.pwpB) FROM=39n TO=56n
.meas tran ecyc1_X_SC_10_100_100_10 INTEG V(X_SC_10_100_100_10.pwpC) FROM=99n TO=123n
.meas tran ecyc2_X_SC_10_100_100_10 INTEG V(X_SC_10_100_100_10.pwpC) FROM=123n TO=139n
.meas tran ecycT_X_SC_10_100_100_10 INTEG V(X_SC_10_100_100_10.pwpC) FROM=99n TO=139n
.meas tran vraA_X_SC_10_100_100_10 MAX V(X_SC_10_100_100_10.rAp) FROM=9n TO=26n
.meas tran vraB_X_SC_10_100_100_10 MIN V(X_SC_10_100_100_10.rBq) FROM=39n TO=56n
.meas tran vlnA_X_SC_10_100_100_10 MAX V(X_SC_10_100_100_10.drvA) FROM=9n TO=26n
.meas tran epush_X_SC_10_100_500_05 INTEG V(X_SC_10_100_500_05.pwpA) FROM=9n TO=26n
.meas tran epull_X_SC_10_100_500_05 INTEG V(X_SC_10_100_500_05.pwpB) FROM=39n TO=56n
.meas tran ecyc1_X_SC_10_100_500_05 INTEG V(X_SC_10_100_500_05.pwpC) FROM=99n TO=123n
.meas tran ecyc2_X_SC_10_100_500_05 INTEG V(X_SC_10_100_500_05.pwpC) FROM=123n TO=139n
.meas tran ecycT_X_SC_10_100_500_05 INTEG V(X_SC_10_100_500_05.pwpC) FROM=99n TO=139n
.meas tran vraA_X_SC_10_100_500_05 MAX V(X_SC_10_100_500_05.rAp) FROM=9n TO=26n
.meas tran vraB_X_SC_10_100_500_05 MIN V(X_SC_10_100_500_05.rBq) FROM=39n TO=56n
.meas tran vlnA_X_SC_10_100_500_05 MAX V(X_SC_10_100_500_05.drvA) FROM=9n TO=26n
.meas tran epush_X_SC_10_100_500_10 INTEG V(X_SC_10_100_500_10.pwpA) FROM=9n TO=26n
.meas tran epull_X_SC_10_100_500_10 INTEG V(X_SC_10_100_500_10.pwpB) FROM=39n TO=56n
.meas tran ecyc1_X_SC_10_100_500_10 INTEG V(X_SC_10_100_500_10.pwpC) FROM=99n TO=123n
.meas tran ecyc2_X_SC_10_100_500_10 INTEG V(X_SC_10_100_500_10.pwpC) FROM=123n TO=139n
.meas tran ecycT_X_SC_10_100_500_10 INTEG V(X_SC_10_100_500_10.pwpC) FROM=99n TO=139n
.meas tran vraA_X_SC_10_100_500_10 MAX V(X_SC_10_100_500_10.rAp) FROM=9n TO=26n
.meas tran vraB_X_SC_10_100_500_10 MIN V(X_SC_10_100_500_10.rBq) FROM=39n TO=56n
.meas tran vlnA_X_SC_10_100_500_10 MAX V(X_SC_10_100_500_10.drvA) FROM=9n TO=26n
.meas tran enull INTEG V(pwpN) FROM=70n TO=90n
.meas tran vra_null MAX V(rAn) FROM=70n TO=90n
.meas tran vrb_null MIN V(rBn) FROM=70n TO=90n
.end
