* =====================================================================
* tsum_cell.cir  --  the mod-3 sum (⊕, balanced ternary addition) in
* DIODE-DIRECTION form, with an EXPLICIT NULL-RAIL detector.
*
* WHY THIS NETLIST EXISTS
*   The diode-direction receiver (two antiparallel diodes) reads push vs
*   pull vs null: rA fires on push (0 -> +Vrail), rB fires on pull
*   (0 -> -Vrail), and NEITHER fires on null (no current -> free).  That
*   cleanly produces the 2-input lattice gates (dd_not/dd_nand/dd_nor/
*   dd_min/dd_max, diode_gates.cir, 54.2-122.2 fJ/toggle).  But the
*   mod-3 sum is an F3 FIELD op, not a lattice op: it needs the null as
*   an EXPLICIT INPUT -- the sum's push term is
*       sum.push = (a pull & b pull) | (a null & b push) | (a push & b null)
*   which requires the signal  null_a = NOT(push_a OR pull_a).  The
*   direction receiver produces null only as the JOINT ABSENCE of its two
*   rails -- it has no null rail to feed the logic.  That is the single
*   gap this cell closes (and the reason diode_gates.cir declared the sum
*   "not tractable in pure diode form").
*
* THE DESIGN (diode-direction receiver + an explicit null-rail detector)
*   Per input wire w:
*     dd_recv : two opposite diodes -> rA (push rail), rB (pull rail).
*     push restore : N_HI(g=rA, src=-VDD) is ON only when rA > +0.4 V
*                    (push) -> midp pulls to -VDD; keeper holds +VDD
*                    otherwise; p = NOT(midp)  => p = +VDD iff push.
*     pull restore : P_HI(g=rB, src=+VDD) is ON only when rB < -0.4 V
*                    (pull) -> n pulls to +VDD; keeper holds -VDD
*                    otherwise             => n = +VDD iff pull.
*     null rail    : z = NOT(p OR n) = +VDD iff null.   <-- the new piece
*   Sum logic (one-hot p/n/z, static CMOS on +/-VDD rails):
*     sp = (na&nb) | (za&pb) | (pa&zb)
*     sn = (pa&pb) | (za&nb) | (na&zb)
*   Output driver (dead-zone push-pull, same as polar_gates.cir driver):
*     wout = +VDD on sp (gp=NOT sp, active-low), -VDD on sn, 0 on null.
*
*   The elevated-|Vt| dead zone (Vt=1.4 V) is what makes the null a DEAD
*   ZONE in the receiver: at null both rails sit at 0, so both elevated-Vt
*   devices are OFF and the null rail is generated by NOR(p,n) -- a clean
*   static decision, NOT a 0-V saddle comparator.  No clock, no sense amp.
*
* FAIR-FIGHT HONESTY (same rules as diode_gates.cir / polar_gates.cir)
*   - Real output driver (V*I counted over a full assert+release cycle).
*   - Real (passive) receiver: next stage's diode rectifier is the load.
*   - Inputs are ideal voltage sources (previous stage abstracted).
*   - LEVEL=1 models, no body diodes, no mismatch.
*   - Same +/-VDD = +/-1.0 V rails for binary and ternary.
*   - Cheapest ternary toggle (null<->+1) measured; the +1<->-1 full-swing
*     toggle is ALSO measured (costs ~2x) and reported separately.
*
* DEVICE COUNTING: "diode" = rectifier diode (D); "transistor" = MOSFET.
*   Keepers (R,C) are passive and not counted.
*
* =====================================================================

.options reltol=1e-3 abstol=1e-15 vntol=1e-6

.param VDD   = 1.0
.param Rwire = 100
.param CL    = 10f          ; one output wire drives ~1 next-gate input
.param Rterm = 100k         ; null-return termination on every polar wire
.param T_C0 = 95n           ; full-cycle window: assert @100n, release @105n
.param T_C1 = 135n
.param T_Q0 = 10n           ; quiet (held-null / idle) window
.param T_Q1 = 85n

* ---------------- models ---------------------------------------------
* standard CMOS (verbatim diode_gates.cir)
.model NMOS1 NMOS(LEVEL=1 VTO=0.4  KP=200u LAMBDA=0.05 TOX=2n)
.model PMOS1 PMOS(LEVEL=1 VTO=-0.4 KP=100u LAMBDA=0.05 TOX=2n)
* elevated-Vt dead-zone devices: |Vt|=1.4 V sits BETWEEN VDD (off at null)
* and VDD+Vrail (on when the rail fires).  LEVEL=1 hard cutoff => true
* dead zone (no subthreshold).
.model N_HI  NMOS(LEVEL=1 VTO=1.4  KP=200u LAMBDA=0.05 TOX=2n)
.model P_HI  PMOS(LEVEL=1 VTO=-1.4 KP=100u LAMBDA=0.05 TOX=2n)
* rectifier diode (Schottky-ish, low forward drop ~0.43 V at 1 mA)
.model DD D (IS=1e-9 RS=200 CJO=2f TT=1p N=1.05)

* ---------------- diode-direction receiver (passive, per input wire) ---
* rA = push rail (0 -> +Vrail), rB = pull rail (0 -> -Vrail).
.subckt dd_recv win rA rB
D1 win rA DD
D2 rB win DD
RkA rA 0 100k
RkB rB 0 100k
CkA rA 0 2f
CkB rB 0 2f
.ends

* ---------------- static CMOS primitives (bipolar rails +/-VDD) --------
.subckt inv in out vdd vss
Mp out in vdd vdd PMOS1 W=4u  L=0.18u
Mn out in vss vss NMOS1 W=2u  L=0.18u
.ends

.subckt nand2 a b out vdd vss
Mp1 out a vdd vdd PMOS1 W=4u  L=0.18u
Mp2 out b vdd vdd PMOS1 W=4u  L=0.18u
Mn1 out a mid vss NMOS1 W=4u  L=0.18u
Mn2 mid b vss vss NMOS1 W=4u  L=0.18u
Cmid mid 0 1f
.ends

.subckt nor2 a b out vdd vss
Mp1 mid a vdd vdd PMOS1 W=8u  L=0.18u
Mp2 out b mid vdd PMOS1 W=8u  L=0.18u
Mn1 out a vss vss NMOS1 W=2u  L=0.18u
Mn2 out b vss vss NMOS1 W=2u  L=0.18u
Cmid mid 0 1f
.ends

.subckt and2 a b out vdd vss
X1 a b mid vdd vss nand2
X2 mid out vdd vss inv
.ends

.subckt or2 a b out vdd vss
X1 a b mid vdd vss nor2
X2 mid out vdd vss inv
.ends

.subckt or3 a b c out vdd vss
X1 a b m1 vdd vss or2
X2 m1 c out vdd vss or2
.ends

* ---------------- push-pull output driver (2 T, dead-zone null) --------
* gp = active-low push enable (PMOS on when gp = -VDD),
* gn = active-high pull enable (NMOS on when gn = +VDD).
* null = (gp = +VDD, gn = -VDD): both off, wire returns to 0 via Rterm.
.subckt driver gp gn out vdd vss
Mp out gp vdd vdd PMOS1 W=4u  L=0.18u
Mn out gn vss vss NMOS1 W=2u  L=0.18u
.ends

* =====================================================================
* TERNARY RECEIVER: polar wire -> one-hot {p, n, z} at full +/-VDD swing
*   p = +VDD iff push, n = +VDD iff pull, z = +VDD iff null (else -VDD).
*
*   The restore stages are COMPLEMENTARY push-pull pairs with NO keeper,
*   so there is no static contention (held-null idle stays ~0):
*     push restore: PMOS1(g=rA) ON when rA<+0.6 (not push) -> midp=+VDD
*                   N_HI (g=rA) ON when rA>+0.4 (push)     -> midp=-VDD
*                   (gap 0.4..0.6 => no overlap) ; p = NOT(midp)
*     pull restore: P_HI (g=rB) ON when rB<-0.4 (pull)     -> n=+VDD
*                   NMOS1(g=rB) ON when rB>-0.6 (not pull) -> n=-VDD
*   Device count: 2 D (diode) + PMOS1 + N_HI + 2 (inv) + P_HI + NMOS1
*              + 4 (nor2) = 10 T + 2 D per input.
* =====================================================================
.subckt t_recv w p n z vdd vss
Xr w ra rb dd_recv
* push restore: midp = NOT(push); p = NOT(midp) = +VDD iff push
Mpu midp ra vdd vdd PMOS1 W=4u L=0.18u
Mpd midp ra vss vss N_HI  W=4u L=0.18u
Xi midp p vdd vss inv
* pull restore: n = +VDD iff pull
Mnu n rb vdd vdd P_HI  W=4u L=0.18u
Mnd n rb vss vss NMOS1 W=4u L=0.18u
* null rail: z = NOT(p OR n)
Xz p n z vdd vss nor2
.ends

* =====================================================================
* MOD-3 SUM CELL (the deliverable).  Devices: 2 x t_recv (20 T + 4 D)
*   + 6 and2 + 2 or3 (60 T) + 1 inv (2 T) + driver (2 T)
*   = 84 T + 4 D = 88 devices.
* =====================================================================
.subckt tsum wa wb wout vdd vss
* per-input ternary receiver (diode-direction + null rail)
Xra wa pa na za vdd vss t_recv
Xrb wb pb nb zb vdd vss t_recv
* sum.push = (na&nb) | (za&pb) | (pa&zb)
Xp1 na nb t1 vdd vss and2
Xp2 za pb t2 vdd vss and2
Xp3 pa zb t3 vdd vss and2
Xpor t1 t2 t3 sp vdd vss or3
* sum.pull = (pa&pb) | (za&nb) | (na&zb)
Xn1 pa pb t4 vdd vss and2
Xn2 za nb t5 vdd vss and2
Xn3 na zb t6 vdd vss and2
Xnor t4 t5 t6 sn vdd vss or3
* output driver: push active-low (gp = NOT sp), pull active-high (gn = sn)
Xgi sp gp vdd vss inv
Xdrv gp sn wout vdd vss driver
.ends

* ---------------- binary references (same harness, same rails) --------
* 2-input XOR (the true 2-input analog of the mod-3 sum): 14 T.
.subckt bin_xor2 a b out vdd vss
Xa a b mid1 vdd vss and2
Xn a b mid2 vdd vss nor2
Xo mid1 mid2 out vdd vss nor2
.ends

* binary full adder (sum + carry): 2 x bin_xor2 + 3 x and2 + 1 x or2
*   = 14+14+18 = 46 T.  (gate_area.md's synthesized reference is 2 cells
*   / 33.78 um^2 ~= 22-28 T; this harness FA is unoptimized NAND/NOR form.)
.subckt bin_fa a b cin sum cout vdd vss
Xs1 a b s1 vdd vss bin_xor2
Xs2 s1 cin sum vdd vss bin_xor2
Xc1 a b c1 vdd vss and2
Xc2 cin s1 c2 vdd vss and2
Xco c1 c2 cout vdd vss or2
.ends

* =====================================================================
* ENERGY INSTANCES
* =====================================================================
* --- E1: binary FULL ADDER (fair-fight reference; a=1, b toggles, cin=0)
*     sum = a XOR b toggles 1->0->1 ; carry = a AND b toggles 0->1->0.
* ---
VDDb1 vddb1 0 DC {VDD}
VSSb1 vssb1 0 DC {-VDD}
Va1 a1 0 DC {VDD}
Vcin1 cin1 0 DC {-VDD}
Vb1 b1 0 PULSE({-VDD} {VDD} 100n 0.2n 0.2n 20n 200n)
Xb1 a1 b1 cin1 sum1 cout1 vddb1 vssb1 bin_fa
Rws1 sum1 ls1 {Rwire}
Cls1 ls1 0 {CL}
Rwc1 cout1 lc1 {Rwire}
Clc1 lc1 0 {CL}
Bp1 p1 0 V = -(V(vddb1)*I(VDDb1) + V(vssb1)*I(VSSb1))

* --- E2: binary XOR2 (2-input analog; a=1, b toggles 0->1->0) ---
VDDb2 vddb2 0 DC {VDD}
VSSb2 vssb2 0 DC {-VDD}
Va2 a2 0 DC {VDD}
Vb2 b2 0 PULSE({-VDD} {VDD} 100n 0.2n 0.2n 20n 200n)
Xb2 a2 b2 out2 vddb2 vssb2 bin_xor2
Rw2 out2 l2 {Rwire}
Cl2 l2 0 {CL}
Bp2 p2 0 V = -(V(vddb2)*I(VDDb2) + V(vssb2)*I(VSSb2))

* --- E3: TERNARY mod-3 sum, CHEAPEST toggle (a=null, b: null->+1->null)
*     sum = 0 XOR b = b, so wout toggles null->+1->null.
* ---
VDDt3 vddt3 0 DC {VDD}
VSSt3 vsst3 0 DC {-VDD}
Vat3 at3 0 DC 0
Vbt3 bt3 0 PULSE(0 {VDD} 100n 0.2n 0.2n 5n 200n)
Xt3 at3 bt3 wout3 vddt3 vsst3 tsum
Rw3 wout3 l3 {Rwire}
Cl3 l3 0 {CL}
Rterm3 l3 0 {Rterm}
Xrec3 l3 ra3 rb3 dd_recv        ; next gate's input (passive load)
Bp3 p3 0 V = -(V(vddt3)*I(VDDt3) + V(vsst3)*I(VSSt3))

* --- E4: TERNARY mod-3 sum, FULL-SWING toggle (a=+1, b: null->+1->null)
*     sum = +1 XOR b:  null->+1 gives +1, +1->+1 gives -1 => wout +1->-1.
* ---
VDDt4 vddt4 0 DC {VDD}
VSSt4 vsst4 0 DC {-VDD}
Vat4 at4 0 DC {VDD}
Vbt4 bt4 0 PULSE(0 {VDD} 100n 0.2n 0.2n 5n 200n)
Xt4 at4 bt4 wout4 vddt4 vsst4 tsum
Rw4 wout4 l4 {Rwire}
Cl4 l4 0 {CL}
Rterm4 l4 0 {Rterm}
Xrec4 l4 ra4 rb4 dd_recv
Bp4 p4 0 V = -(V(vddt4)*I(VDDt4) + V(vsst4)*I(VSSt4))

* =====================================================================
* TRUTH TABLE: all 9 input pairs, DC inputs, output read after settling.
*   Balanced input values: -1 = -VDD, 0 = 0, +1 = +VDD.
* =====================================================================
VDDt vddt 0 DC {VDD}
VSSt vsst 0 DC {-VDD}
* TT1: (-1,-1) -> +1
Va1t a1t 0 DC {-VDD}
Vb1t b1t 0 DC {-VDD}
Xtt1 a1t b1t o1 vddt vsst tsum
Rw1t o1 l1t {Rwire}
Cl1t l1t 0 {CL}
Rterm1t l1t 0 {Rterm}
* TT2: (-1,0) -> -1
Va2t a2t 0 DC {-VDD}
Vb2t b2t 0 DC 0
Xtt2 a2t b2t o2 vddt vsst tsum
Rw2t o2 l2t {Rwire}
Cl2t l2t 0 {CL}
Rterm2t l2t 0 {Rterm}
* TT3: (-1,+1) -> 0
Va3t a3t 0 DC {-VDD}
Vb3t b3t 0 DC {VDD}
Xtt3 a3t b3t o3 vddt vsst tsum
Rw3t o3 l3t {Rwire}
Cl3t l3t 0 {CL}
Rterm3t l3t 0 {Rterm}
* TT4: (0,-1) -> -1
Va4t a4t 0 DC 0
Vb4t b4t 0 DC {-VDD}
Xtt4 a4t b4t o4 vddt vsst tsum
Rw4t o4 l4t {Rwire}
Cl4t l4t 0 {CL}
Rterm4t l4t 0 {Rterm}
* TT5: (0,0) -> 0
Va5t a5t 0 DC 0
Vb5t b5t 0 DC 0
Xtt5 a5t b5t o5 vddt vsst tsum
Rw5t o5 l5t {Rwire}
Cl5t l5t 0 {CL}
Rterm5t l5t 0 {Rterm}
* TT6: (0,+1) -> +1
Va6t a6t 0 DC 0
Vb6t b6t 0 DC {VDD}
Xtt6 a6t b6t o6 vddt vsst tsum
Rw6t o6 l6t {Rwire}
Cl6t l6t 0 {CL}
Rterm6t l6t 0 {Rterm}
* TT7: (+1,-1) -> 0
Va7t a7t 0 DC {VDD}
Vb7t b7t 0 DC {-VDD}
Xtt7 a7t b7t o7 vddt vsst tsum
Rw7t o7 l7t {Rwire}
Cl7t l7t 0 {CL}
Rterm7t l7t 0 {Rterm}
* TT8: (+1,0) -> +1
Va8t a8t 0 DC {VDD}
Vb8t b8t 0 DC 0
Xtt8 a8t b8t o8 vddt vsst tsum
Rw8t o8 l8t {Rwire}
Cl8t l8t 0 {CL}
Rterm8t l8t 0 {Rterm}
* TT9: (+1,+1) -> -1
Va9t a9t 0 DC {VDD}
Vb9t b9t 0 DC {VDD}
Xtt9 a9t b9t o9 vddt vsst tsum
Rw9t o9 l9t {Rwire}
Cl9t l9t 0 {CL}
Rterm9t l9t 0 {Rterm}

* =====================================================================
* SIMULATION + MEASUREMENTS
* =====================================================================
.tran 20p 140n

* --- E_gate: supply energy over one full output cycle (J) ---
.meas tran egate_fa   INTEG V(p1) FROM={T_C0} TO={T_C1}
.meas tran egate_xor2 INTEG V(p2) FROM={T_C0} TO={T_C1}
.meas tran egate_t3   INTEG V(p3) FROM={T_C0} TO={T_C1}
.meas tran egate_t4   INTEG V(p4) FROM={T_C0} TO={T_C1}

* --- per-toggle = full cycle / 2 ---
.meas tran ept_fa   PARAM = 'egate_fa/2'
.meas tran ept_xor2 PARAM = 'egate_xor2/2'
.meas tran ept_t3   PARAM = 'egate_t3/2'
.meas tran ept_t4   PARAM = 'egate_t4/2'

* --- binary output checkpoints (assert @111n, release @131n) ---
.meas tran vsum_fa_r FIND V(ls1) AT=111n
.meas tran vsum_fa_f FIND V(ls1) AT=131n
.meas tran vcar_fa_r FIND V(lc1) AT=111n
.meas tran vxor2_r   FIND V(l2)  AT=111n
.meas tran vxor2_f   FIND V(l2)  AT=131n

* --- ternary energy-instance checkpoints (pulse @100n, null @110n) ---
.meas tran vw3_r FIND V(l3) AT=103n
.meas tran vw3_f FIND V(l3) AT=110n
.meas tran vw4_r FIND V(l4) AT=103n
.meas tran vw4_f FIND V(l4) AT=110n

* --- quiet-window energy ---
* eq_t3 is the TRUE held-null idle (a=null, output null): expect ~0.
* eq_t4 is NOT null-idle: a=+1 holds the output at +1 in the quiet window,
*   so it includes the Rterm hold current -- a held-output cost, not a leak.
.meas tran eq_fa   INTEG V(p1) FROM={T_Q0} TO={T_Q1}
.meas tran eq_xor2 INTEG V(p2) FROM={T_Q0} TO={T_Q1}
.meas tran eq_t3   INTEG V(p3) FROM={T_Q0} TO={T_Q1}
.meas tran eq_t4   INTEG V(p4) FROM={T_Q0} TO={T_Q1}

* --- truth table: 9 output values (read at 130n, after settling) ---
.meas tran tt1 FIND V(l1t) AT=130n
.meas tran tt2 FIND V(l2t) AT=130n
.meas tran tt3 FIND V(l3t) AT=130n
.meas tran tt4 FIND V(l4t) AT=130n
.meas tran tt5 FIND V(l5t) AT=130n
.meas tran tt6 FIND V(l6t) AT=130n
.meas tran tt7 FIND V(l7t) AT=130n
.meas tran tt8 FIND V(l8t) AT=130n
.meas tran tt9 FIND V(l9t) AT=130n

.end
